// ngspice S element / `.model sw`: voltage-controlled switch.
// Spec: docs/tline-and-switch.md §1.2 (FSM) and §3 (`sw_update_state`/`sw_eval`).
//
// The four-state hysteresis FSM needs memory across evaluations. Verilog-A
// gives that only to variables assigned inside an event block (LRM §5.10), and
// FastVAF now honours it — a plain `if (u > hi) state = ...` in the analog
// block is still re-derived from its initializer on every evaluation. Hence the
// split below, which is what makes this correct in DC *and* transient:
//
//   OUTSIDE the window the state is a pure function of the control value, so it
//   needs no memory at all and is computed inline. That is what makes `.op` and
//   `.dc` right: `cross` events only fire when time advances, so a memory-only
//   formulation would sit at its seed value through an entire sweep.
//
//   INSIDE the window the state IS the memory — the held variable `latched`,
//   written only from `@(initial_step)` and the `@(cross(...))` edges.
//
// Codes follow §1.2: 2 = HYST_OFF, 3 = HYST_ON, with ON = code > 2.5. The two
// REALLY_* states of swload.c are not stored: outside the band the position is
// recomputed from `u` every evaluation, so they carry no information we need.
module vswitch(p, n, cp, cn);
    inout p, n, cp, cn;
    electrical p, n, cp, cn;

    parameter real vt   = 0.0;                  // V   threshold
    parameter real vh   = 0.0;                  // V   hysteresis half-width
    parameter real ron  = 1.0    from (0:inf);  // ohm on resistance
    parameter real roff = 1.0e12 from (0:inf);  // ohm off resistance (1/gmin)
    // Instance IC (`.model sw ... ON`/`OFF`): seeds the in-window state so a
    // switch that starts inside the band has a defined position.
    parameter integer ic = 0;                   // >0 = start ON

    integer latched;   // held across evaluations: the in-window memory
    integer on;
    real u, hi, lo, gon, goff;

    analog begin
        // §3: g_on/g_off are model-level scalars, no node voltage in sight.
        gon  = 1.0 / ron;
        goff = 1.0 / roff;

        // Both signs of vh share the same rails: the §1.2 negative-hysteresis
        // window is [vt+vh, vt-vh], the same pair with the roles swapped, so
        // |vh| gives the band either way and the sign only selects what happens
        // on entry (below).
        hi = vt + abs(vh);
        lo = vt - abs(vh);
        u  = V(cp, cn);

        @(initial_step) latched = (ic > 0) ? 3 : 2;

        // Crossing OUT of the band latches the rail it left by; crossing IN is
        // what the sign of vh distinguishes. vh >= 0: the band remembers, so
        // entering changes nothing. vh < 0: the band is unstable and entering
        // from a rail flips to the opposite one (§1.2 oscillator primitive).
        @(cross(u - hi, +1)) latched = 3;                    // -> HYST_ON
        @(cross(u - lo, -1)) latched = 2;                    // -> HYST_OFF
        @(cross(u - hi, -1)) latched = (vh < 0.0) ? 2 : 3;   // ON rail -> band
        @(cross(u - lo, +1)) latched = (vh < 0.0) ? 3 : 2;   // OFF rail -> band

        // Outside the band: memoryless. Inside: the latch.
        if (u > hi) on = 1;
        else if (u < lo) on = 0;
        else on = (latched > 2.5) ? 1 : 0;

        // §3 sw_eval: piecewise-constant stamp, dG/du deliberately 0 — the
        // state decision sits outside the linearization, as in swload.c.
        I(p, n) <+ (on ? gon : goff) * V(p, n);
    end
endmodule
