discipline ch3_domainless; enddiscipline
module ch3_domainless_structural; ch3_domainless link; endmodule
