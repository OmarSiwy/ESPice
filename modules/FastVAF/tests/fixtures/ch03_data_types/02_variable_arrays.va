module ch03_variable_arrays(p, n);
    inout p, n;
    electrical p, n;
    integer flags[0:2];
    real gains[0:2];

    analog begin
        flags[0] = 1;
        gains[0] = 1.5;
        I(p, n) <+ flags[0] * gains[0] * V(p, n);
    end
endmodule
