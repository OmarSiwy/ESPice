module ch3_time_params(p); inout p; electrical p; parameter time delay=1n; parameter realtime ratio=1.25; time ticks; realtime value; analog begin value=ratio; I(p)<+value+0.0*V(p); end endmodule
// LRM 3.2/3.4: `time` and `realtime` are legal data types for variables and
// parameters, so this must COMPILE.
