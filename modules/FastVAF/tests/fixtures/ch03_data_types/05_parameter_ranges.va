module ch03_parameter_ranges(p, n);
    inout p, n;
    electrical p, n;
    parameter real neg_rail = -15 from [-50:0);
    parameter integer pos_rail = 15 from (0:50);
    parameter real gain = 1 from [1:1000];
    parameter real ranged = 0 from [0:inf) exclude (10:20) exclude (30:40];
    parameter real nonzero = 1.0 exclude 0;

    analog I(p, n) <+ gain * V(p, n) + nonzero + ranged + neg_rail + pos_rail;
endmodule
