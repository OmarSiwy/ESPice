module ch03_string_parameter_range;
    parameter string device_type = "NMOS" from '{"NMOS", "PMOS"};
    parameter string filename = "output.dat" exclude '{""};
endmodule
