module ch04_user_function(p, n);
    inout p, n;
    electrical p, n;

    analog function real max_value;
        input real first, second;
        begin
            max_value = first > second ? first : second;
        end
    endfunction

    analog I(p, n) <+ max_value(V(p, n), 0.0);
endmodule
