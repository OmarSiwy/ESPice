module ch04_logical_and(p, n); inout p, n; electrical p, n; analog I(p, n) <+ ((V(p, n) > 0.0) && (V(p, n) < 2.0)); endmodule
