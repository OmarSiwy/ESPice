module ch04_laplace_filters(p, n);
    inout p, n;
    electrical p, n;

    analog begin
        I(p, n) <+ laplace_zp(V(p, n), '{-1.0, 0.0}, '{-1.0, -1.0, -1.0, 1.0});
        I(p, n) <+ laplace_zd(V(p, n), '{-1.0, 0.0}, '{1.0, 2.0});
        I(p, n) <+ laplace_np(V(p, n), '{0.0, 1.0}, '{-1.0, 0.0});
        I(p, n) <+ laplace_nd(V(p, n), '{0.0, 1.0}, '{1.0, 2.0, 1.0});
    end
endmodule
