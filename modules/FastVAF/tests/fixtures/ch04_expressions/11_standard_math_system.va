module ch04_standard_math_system(p, n);
    inout p, n;
    electrical p, n;
    real x, value;

    analog begin
        x = $abs(V(p, n)) + 1.0;
        value = $ln(x) + $log10(x) + $exp(x) + $sqrt(x) +
                $min(x, 2.0) + $max(x, 2.0) + $pow(x, 2.0) +
                $floor(x) + $ceil(x);
        I(p, n) <+ value;
    end
endmodule
