module ch04_exp(p, n); inout p, n; electrical p, n; analog I(p, n) <+ exp(V(p, n)); endmodule
