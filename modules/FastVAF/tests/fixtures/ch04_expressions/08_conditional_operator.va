module ch04_conditional_operator(p, n);
    inout p, n;
    electrical p, n;
    real value;

    analog begin
        value = V(p, n) > 1.0 ? 10.0 : V(p, n) < -1.0 ? -10.0 : 0.0;
        I(p, n) <+ value;
    end
endmodule
