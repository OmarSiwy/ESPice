module ch04_precedence_associativity(p, n);
    inout p, n;
    electrical p, n;
    real a, b, c, value;

    analog begin
        a = 12.0;
        b = 6.0;
        c = 3.0;
        value = a + b / c + (a + b) / c + a - b - c;
        I(p, n) <+ value;
    end
endmodule
