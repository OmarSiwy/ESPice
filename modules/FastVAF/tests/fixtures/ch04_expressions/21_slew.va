module ch04_slew(p, n);
    inout p, n;
    electrical p, n;

    analog I(p, n) <+ slew(V(p, n), 1e6, -2e6);
endmodule
