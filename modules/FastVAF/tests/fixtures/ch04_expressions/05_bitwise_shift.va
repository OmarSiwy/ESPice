module ch04_bitwise_shift(p, n);
    inout p, n;
    electrical p, n;
    integer a, b, value;

    analog begin
        a = 5;
        b = 3;
        value = (~a) + (a & b) + (a | b) + (a ^ b) + (a ^~ b) +
                (a ~^ b) + (a << 2) + (a >> 1) + (a <<< 1) + (a >>> 1);
        I(p, n) <+ value;
    end
endmodule
