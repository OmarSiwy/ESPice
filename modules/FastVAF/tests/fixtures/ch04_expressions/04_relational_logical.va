module ch04_relational_logical(p, n);
    inout p, n;
    electrical p, n;
    real a, b;
    integer value;

    analog begin
        a = V(p, n);
        b = 1.0;
        value = (a < b) + (a <= b) + (a > b) + (a >= b) +
                (a == b) + (a != b) + !(a == 0.0) +
                ((a > 0.0) && (b > 0.0)) + ((a < 0.0) || (b > 0.0));
        I(p, n) <+ value;
    end
endmodule
