module ch4_fn_indirect(p); inout p; electrical p; analog function real first; input x; real x; first=second(x); endfunction analog function real second; input x; real x; second=first(x); endfunction analog I(p)<+V(p); endmodule
