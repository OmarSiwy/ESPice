module ch04_arithmetic_operators(p, n);
    inout p, n;
    electrical p, n;
    real value;

    analog begin
        value = +7.0 + -2.0 * 3.0 - 8.0 / 4.0 + 11 % 3 + 2 ** 3;
        I(p, n) <+ value;
    end
endmodule
