module ch04_logical_equal(p, n); inout p, n; electrical p, n; analog I(p, n) <+ (V(p, n) == 1.0); endmodule
