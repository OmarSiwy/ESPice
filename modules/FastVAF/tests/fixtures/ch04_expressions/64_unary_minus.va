module ch04_unary_minus(p, n); inout p, n; electrical p, n; analog I(p, n) <+ -V(p, n); endmodule
