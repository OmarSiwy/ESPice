module ch04_idtmod(p, n);
    inout p, n;
    electrical p, n;

    analog V(p, n) <+ idtmod(I(p, n), 0.0, 6.283185307179586, 0.0);
endmodule
