module ch04_bitwise_not(p, n); inout p, n; electrical p, n; integer a; analog begin a = ~5; I(p, n) <+ a; end endmodule
