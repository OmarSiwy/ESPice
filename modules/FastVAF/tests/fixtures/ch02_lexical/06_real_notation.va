module ch02_real_notation(p, n);
    inout p, n;
    electrical p, n;
    real decimal_value, scientific_value, signed_exponent;

    analog begin
        decimal_value = 2394.26331;
        scientific_value = 1.2E12;
        signed_exponent = 1.30e-2;
        I(p, n) <+ decimal_value + scientific_value + signed_exponent;
    end
endmodule
