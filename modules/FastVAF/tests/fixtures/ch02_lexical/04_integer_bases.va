module ch02_integer_bases(p, n);
    inout p, n;
    electrical p, n;
    integer decimal_value, binary_value, octal_value, hexadecimal_value;

    analog begin
        decimal_value = 27_195;
        binary_value = 16'b0011_0101_0001_1111;
        octal_value = 12'o7460;
        hexadecimal_value = 32'h12ab_f001;
        I(p, n) <+ decimal_value + binary_value + octal_value + hexadecimal_value;
    end
endmodule
