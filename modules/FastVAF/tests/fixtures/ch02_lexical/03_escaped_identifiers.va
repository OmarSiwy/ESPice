module ch02_escaped_identifiers(p, n);
    inout p, n;
    electrical p, n;
    real \gain+trim ;

    analog begin
        \gain+trim  = 4.0;
        I(p, n) <+ \gain+trim  * V(p, n);
    end
endmodule
