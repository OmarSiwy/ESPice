module combined_electrothermal_dual_discipline(p, n, heat);
  inout p, n; electrical p, n;
  inout heat; thermal heat;
  parameter real resistance = 1k from (0:inf);
  analog begin
    I(p,n) <+ V(p,n) / resistance;
    Pwr(heat) <+ V(p,n) * V(p,n) / resistance;
    Pwr(heat) <+ Temp(heat) / 1e3;
  end
endmodule
