`include "constants.vams"
module combined_noise_and_analysis(p, n);
  inout p, n; electrical p, n;
  parameter real resistance = 1k from (0:inf);
  analog begin
    I(p,n) <+ V(p,n)/resistance;
    if (analysis("noise"))
      I(p,n) <+ white_noise(4.0*`P_K*$temperature/resistance, "thermal");
  end
endmodule
