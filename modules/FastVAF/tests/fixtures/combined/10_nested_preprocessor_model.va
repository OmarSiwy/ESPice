`define FEATURE_A
module combined_nested_preprocessor_model(p, n);
  inout p, n; electrical p, n;
  analog begin
`ifdef FEATURE_A
`ifndef FEATURE_B
    I(p,n) <+ $pow(V(p,n), 2.0);
`else
    I(p,n) <+ V(p,n);
`endif
`else
    I(p,n) <+ 0.0;
`endif
  end
endmodule
