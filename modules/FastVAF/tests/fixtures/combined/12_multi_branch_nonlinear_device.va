module combined_multi_branch_nonlinear_device(d, g, s);
  inout d, g, s;
  electrical d, g, s;
  parameter real beta = 1m from (0:inf);
  parameter real vth = 0.7;
  real overdrive;
  analog begin
    overdrive = max(V(g,s) - vth, 0.0);
    I(d,s) <+ beta * overdrive * overdrive * tanh(V(d,s));
    I(g,s) <+ V(g,s) / 1T;
  end
endmodule
