module combined_file_display_diagnostics(p, n);
  inout p, n; electrical p, n;
  integer fd;
  analog begin
    fd = $fopen("combined.log", "a");
    if (V(p,n) > 1.0) begin
      $fdisplay(fd, "t=%g voltage=%g", $abstime, V(p,n));
      $warning("combined voltage=%g", V(p,n));
    end
    $fflush(fd);
    $fclose(fd);
    I(p,n) <+ V(p,n) / 1k;
  end
endmodule
