module combined_named_limiter_nonlinear(p, n);
  inout p, n; electrical p, n;
  parameter real saturation_current = 1e-14 from (0:inf);
  real limited;
  analog begin
    limited = $limit(V(p,n), "pnjlim", $vt, 0.7);
    I(p,n) <+ saturation_current * (limexp(limited / $vt) - 1.0);
    $bound_step(1u);
  end
endmodule
