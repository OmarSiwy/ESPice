module combined_optional_port_hierarchy(p, n, sense);
  inout p, n, sense; electrical p, n, sense;
  parameter real gain = 1.0;
  real environment;
  analog begin
    environment = $mfactor + $xposition + $yposition;
    if ($port_connected(sense))
      I(p,n) <+ gain * V(sense,n) + environment * 0.0;
    else
      I(p,n) <+ gain * V(p,n) + environment * 0.0;
  end
endmodule
