module ch6_scope(p);
  inout p; electrical p; real value;
  analog begin
    value = 1.0;
    begin : inner
      real local_value;
      local_value = value + V(p);
      I(p) <+ local_value;
    end
  end
endmodule
