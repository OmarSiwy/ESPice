module ch6_definition;
  electrical p;
  analog I(p) <+ V(p);
endmodule
