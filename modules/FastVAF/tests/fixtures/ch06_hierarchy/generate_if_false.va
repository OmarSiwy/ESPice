module ch6_gen_false(p); inout p; electrical p; generate if(0) begin I(p)<+1.0; end else begin I(p)<+V(p); end endgenerate endmodule
