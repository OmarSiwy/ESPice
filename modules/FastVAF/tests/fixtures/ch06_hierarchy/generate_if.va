module ch6_generate_if(p);
  inout p; electrical p;
  parameter integer enabled = 1;
  generate
    if (enabled) begin
      I(p) <+ V(p);
    end else begin
      I(p) <+ 0.0;
    end
  endgenerate
endmodule
