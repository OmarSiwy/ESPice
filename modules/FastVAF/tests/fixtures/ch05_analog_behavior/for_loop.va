module ch5_for(p);
  inout p; electrical p; integer i; real x;
  analog begin
    x = 0.0;
    for (i = 0; i < 3; i = i + 1) x = x + V(p);
    I(p) <+ x;
  end
endmodule
