module ch5_above_enable(p, c);
  inout p, c; electrical p, c; real held; integer enabled;
  analog begin
    @(above(V(c) - 0.5, 1p, 1u, enabled)) held = V(p);
    I(p) <+ held;
  end
endmodule
