module ch5_access_one(p);
  inout p; electrical p;
  analog I(p) <+ V(p);
endmodule
