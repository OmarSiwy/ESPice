module ch5_unassigned_arm(p, n, c);
  inout p, n, c; electrical p, n, c;
  analog if (V(c) > 0.5) V(p, n) <+ 0.0;
endmodule
