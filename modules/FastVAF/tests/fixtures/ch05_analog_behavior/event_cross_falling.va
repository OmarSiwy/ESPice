module ch5_cross_fall(p); inout p; electrical p; real x; analog begin @(cross(V(p),-1)) x=V(p); I(p)<+x; end endmodule
