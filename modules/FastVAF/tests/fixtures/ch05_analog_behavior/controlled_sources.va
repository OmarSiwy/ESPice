module ch5_controlled_sources(op, on, cp, cn);
  inout op, on, cp, cn; electrical op, on, cp, cn;
  branch (cp, cn) sensed;
  analog begin
    V(op, on) <+ 2.0 * V(cp, cn);
    I(op, on) <+ 3m * V(cp, cn);
    V(sensed) <+ 4.0 * I(sensed);
    I(op, on) <+ 5.0 * I(sensed);
  end
endmodule
