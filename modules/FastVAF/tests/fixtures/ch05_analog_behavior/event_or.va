module ch5_event_or(p, c);
  inout p, c; electrical p, c; real held;
  analog begin
    @(cross(V(c), +1) or timer(1n, 1n)) held = V(p);
    I(p) <+ held;
  end
endmodule
