// The snapshot records FastVAF's current acceptance without break semantics.
module ch5_jump(p);
  inout p; electrical p; integer i;
  analog for (i = 0; i < 4; i = i + 1) begin
    break;
  end
endmodule
