module ch5_cccs(op,on,cp,cn); inout op,on,cp,cn; electrical op,on,cp,cn; branch(cp,cn) sense; analog begin V(sense)<+0.0; I(op,on)<+2.0*I(sense); end endmodule
