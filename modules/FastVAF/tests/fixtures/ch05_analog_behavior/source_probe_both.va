module ch5_source_probe(p,n); inout p,n; electrical p,n; branch(p,n) b; analog begin V(b)<+10.0*I(b); I(p)<+V(b)+I(b); end endmodule
