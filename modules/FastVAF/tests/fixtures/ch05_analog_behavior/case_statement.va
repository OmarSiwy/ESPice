module ch5_case(p);
  inout p; electrical p; integer mode; real x;
  analog begin
    mode = V(p) > 0.0;
    case (mode)
      0: x = 0.0;
      1, 2: x = 1.0;
      default: x = -1.0;
    endcase
    I(p) <+ x;
  end
endmodule
