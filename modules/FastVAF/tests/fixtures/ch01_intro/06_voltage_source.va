module ch01_voltage_source(p, n);
    inout p, n;
    electrical p, n;
    analog V(p, n) <+ 5.0;
endmodule
