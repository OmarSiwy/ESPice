discipline ch7_discrete;
  domain discrete;
enddiscipline
module ch7_discrete_decl;
  electrical p;
  analog I(p) <+ V(p);
endmodule
