nature ch7_voltage;
  units = "V";
  access = V;
  abstol = 1u;
endnature
nature ch7_current;
  units = "A";
  access = I;
  abstol = 1p;
endnature
discipline ch7_electrical;
  potential ch7_voltage;
  flow ch7_current;
  domain continuous;
enddiscipline
module ch7_custom(p);
  inout p; ch7_electrical p;
  analog I(p) <+ V(p);
endmodule
