module ch8_macro(p, n);
  inout p, n; electrical p, n;
  analog I(p, n) <+ V(p, n);
endmodule
