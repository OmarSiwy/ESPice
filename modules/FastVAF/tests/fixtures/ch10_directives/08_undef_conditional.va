`define TEMP_FEATURE
`undef TEMP_FEATURE
module ch10_undef_conditional(p, n);
  inout p, n; electrical p, n;
  analog begin
`ifdef TEMP_FEATURE
    I(p,n) <+ 2.0*V(p,n);
`else
    I(p,n) <+ V(p,n);
`endif
  end
endmodule
