`begin_keywords "1364-2005"
module ch10_begin_keywords_verilog(sin, n);
  inout sin, n; electrical sin, n;
  analog I(sin,n) <+ V(sin,n);
endmodule
`end_keywords
