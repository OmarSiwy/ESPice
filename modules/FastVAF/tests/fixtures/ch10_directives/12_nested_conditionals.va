`define OUTER_ON
`define INNER_ON
module ch10_nested_conditionals(p, n);
  inout p, n; electrical p, n;
  analog begin
`ifdef OUTER_ON
`ifdef INNER_ON
    I(p,n) <+ 6.0*V(p,n);
`else
    I(p,n) <+ 2.0*V(p,n);
`endif
`else
    I(p,n) <+ V(p,n);
`endif
  end
endmodule
