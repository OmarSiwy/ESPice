module annex_a_expressions(p, n);
    inout p, n;
    electrical p, n;
    parameter real coefficients[0:1] = '{1.0, 2.0};
    real value;

    analog begin
        value = (coefficients[0] + coefficients[1]) * 2.0 ** 3.0;
        value = value > 0.0 ? sin(value) : cos(value);
        I(p, n) <+ value;
    end
endmodule
