module annex_a_indirect(p,c); inout p,c; electrical p,c; analog V(p):V(c)==2.0*V(p); endmodule
