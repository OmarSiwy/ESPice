module ch09_atomic_fseek(p, n);
  inout p, n; electrical p, n;
  integer fd, code;
  analog begin
    fd = $fopen("fixture.dat", "r");
    code = $fseek(fd, 0, 0);
    I(p,n) <+ V(p,n) + code;
  end
endmodule
