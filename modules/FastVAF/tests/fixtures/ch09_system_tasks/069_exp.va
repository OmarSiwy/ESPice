module ch09_atomic_exp(p, n);
  inout p, n; electrical p, n;
  analog I(p,n) <+ V(p,n) + $exp(1.0);
endmodule
