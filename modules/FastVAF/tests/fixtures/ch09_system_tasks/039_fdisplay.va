module ch09_atomic_fdisplay(p, n);
  inout p, n; electrical p, n;
  integer fd;
  analog begin
    fd = $fopen("fixture.log", "a");
    $fdisplay(fd, "value=%g", V(p,n));
    I(p,n) <+ V(p,n);
  end
endmodule
