module ch09_atomic_info(p, n);
  inout p, n; electrical p, n;
  analog begin
    if (V(p,n) > 1.0) $info("voltage=%g", V(p,n));
    I(p,n) <+ V(p,n);
  end
endmodule
