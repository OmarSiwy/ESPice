module ch09_atomic_realtobits(p, n);
  inout p, n; electrical p, n;
  analog I(p,n) <+ $realtobits(V(p,n)) + V(p,n);
endmodule
