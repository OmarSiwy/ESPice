module ch09_atomic_cos(p, n);
  inout p, n; electrical p, n;
  analog I(p,n) <+ V(p,n) + $cos(V(p,n));
endmodule
