// NONCONFORMING ACCEPTANCE SNAPSHOT: $driver_delay is valid only in the digital context of a connectmodule.
module ch09_atomic_driver_delay(p, n);
  inout p, n; electrical p, n;
  analog I(p,n) <+ V(p,n) + $driver_delay(p,0);
endmodule
