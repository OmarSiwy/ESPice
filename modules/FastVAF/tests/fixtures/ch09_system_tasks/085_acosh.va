module ch09_atomic_acosh(p, n);
  inout p, n; electrical p, n;
  analog I(p,n) <+ V(p,n) + $acosh(abs(V(p,n)) + 1.0);
endmodule
