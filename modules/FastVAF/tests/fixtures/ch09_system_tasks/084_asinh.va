module ch09_atomic_asinh(p, n);
  inout p, n; electrical p, n;
  analog I(p,n) <+ V(p,n) + $asinh(V(p,n));
endmodule
