module ch09_atomic_stop(p, n);
  inout p, n; electrical p, n;
  analog begin
    if (V(p,n) > 1.0) $stop(1);
    I(p,n) <+ V(p,n);
  end
endmodule
