module ch09_atomic_atan(p, n);
  inout p, n; electrical p, n;
  analog I(p,n) <+ V(p,n) + $atan(V(p,n));
endmodule
