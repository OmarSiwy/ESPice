module ch09_atomic_fscanf(p, n);
  inout p, n; electrical p, n;
  integer fd, code, value;
  analog begin
    fd = $fopen("fixture.dat", "r");
    code = $fscanf(fd, "%d", value);
    I(p,n) <+ V(p,n) + code + value;
  end
endmodule
