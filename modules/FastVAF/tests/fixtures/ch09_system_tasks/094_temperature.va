module ch09_atomic_temperature(p, n);
  inout p, n; electrical p, n;
  analog I(p,n) <+ V(p,n) + $temperature;
endmodule
