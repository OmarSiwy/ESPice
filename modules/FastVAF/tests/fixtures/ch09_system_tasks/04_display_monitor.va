module ch09_display_monitor(p, n);
  inout p, n; electrical p, n;
  analog begin
    $monitor("monitored=%f", V(p,n));
    I(p,n) <+ V(p,n);
  end
endmodule
