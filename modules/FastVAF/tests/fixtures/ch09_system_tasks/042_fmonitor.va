module ch09_atomic_fmonitor(p, n);
  inout p, n; electrical p, n;
  integer fd;
  analog begin
    fd = $fopen("fixture.log", "a");
    $fmonitor(fd, "value=%g", V(p,n));
    I(p,n) <+ V(p,n);
  end
endmodule
