module ch09_finish_stop(p, n);
  inout p, n; electrical p, n;
  analog begin
    if (V(p,n) > 2.0) $stop(1);
    if (V(p,n) > 3.0) $finish(2);
    I(p,n) <+ V(p,n);
  end
endmodule
