module ch09_atomic_mfactor(p, n);
  inout p, n; electrical p, n;
  analog I(p,n) <+ V(p,n) + $mfactor;
endmodule
