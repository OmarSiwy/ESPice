// NONCONFORMING ACCEPTANCE SNAPSHOT: $driver_next_strength is valid only in the digital context of a connectmodule.
module ch09_atomic_driver_next_strength(p, n);
  inout p, n; electrical p, n;
  analog I(p,n) <+ V(p,n) + $driver_next_strength(p,0);
endmodule
