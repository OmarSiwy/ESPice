module ch09_atomic_vt_temperature(p, n);
  inout p, n; electrical p, n;
  analog I(p,n) <+ V(p,n) + $vt(300.0);
endmodule
