module ch09_limit_named(p, n);
  inout p, n; electrical p, n;
  real limited;
  analog begin
    limited = $limit(V(p,n), "pnjlim", $vt, 0.7);
    I(p,n) <+ limited;
  end
endmodule
