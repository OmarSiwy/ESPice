module ch09_atomic_tan(p, n);
  inout p, n; electrical p, n;
  analog I(p,n) <+ V(p,n) + $tan(V(p,n));
endmodule
