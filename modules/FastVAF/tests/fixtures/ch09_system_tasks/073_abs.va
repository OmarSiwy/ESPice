module ch09_atomic_abs(p, n);
  inout p, n; electrical p, n;
  analog I(p,n) <+ V(p,n) + $abs(-2.0);
endmodule
