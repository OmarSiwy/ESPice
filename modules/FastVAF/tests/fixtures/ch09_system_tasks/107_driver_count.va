// NONCONFORMING ACCEPTANCE SNAPSHOT: $driver_count is connectmodule-only.
module ch09_atomic_driver_count(p, n);
  inout p, n; electrical p, n;
  analog I(p,n) <+ V(p,n) + $driver_count(p);
endmodule
