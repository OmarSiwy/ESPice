module ch09_math_trig(p, n);
  inout p, n; electrical p, n;
  real x;
  analog begin
    x = $sin(V(p,n)) + $cos(V(p,n)) + $tan(V(p,n));
    x = x + $asin(0.5) + $acos(0.5) + $atan(1.0);
    x = x + $sinh(1.0) + $cosh(1.0) + $tanh(1.0);
    x = x + $asinh(1.0) + $acosh(2.0) + $atanh(0.5);
    I(p,n) <+ x;
  end
endmodule
