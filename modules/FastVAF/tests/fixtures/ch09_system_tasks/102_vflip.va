module ch09_atomic_vflip(p, n);
  inout p, n; electrical p, n;
  analog I(p,n) <+ V(p,n) + $vflip;
endmodule
