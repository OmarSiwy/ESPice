module ch09_atomic_hflip(p, n);
  inout p, n; electrical p, n;
  analog I(p,n) <+ V(p,n) + $hflip;
endmodule
