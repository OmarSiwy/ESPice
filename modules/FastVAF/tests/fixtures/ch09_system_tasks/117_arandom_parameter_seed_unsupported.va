// EXPECT: error
module ch09_arandom_parameter_seed_unsupported(p, n);
  inout p, n; electrical p, n;
  parameter integer seed = 7;
  analog I(p,n) <+ $arandom(seed);
endmodule
