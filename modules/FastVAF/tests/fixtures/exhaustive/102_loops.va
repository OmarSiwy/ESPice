// §5.9 loops. `for` and `while` run in the ANALOG block, so their trip count
// must be a compile-time property — the body is unrolled into straight-line MIR.
// A wrong unroll shows up immediately as a wrong sum.
//
//! print none
`include "check.vh"
module ex102_loops(p, n);
  inout p, n;
  electrical p, n;
  integer i;
  real acc;
  real fact;
  analog begin
    acc = 0.0;
    for (i = 1; i <= 5; i = i + 1) acc = acc + i;
    `CHECKX("for sums 1..5", acc, 15.0);

    acc = 0.0;
    i = 0;
    while (i < 4) begin
      acc = acc + 2.0;
      i = i + 1;
    end
    `CHECKX("while runs 4 times", acc, 8.0);

    fact = 1.0;
    for (i = 1; i <= 6; i = i + 1) fact = fact * i;
    `CHECKX("6! by loop", fact, 720.0);

    acc = 0.0;
    for (i = 0; i < 10; i = i + 1) begin
      if (i == 5) i = 100;
      else acc = acc + 1.0;
    end
    `CHECKX("a loop body may change the counter", acc, 5.0);
    I(p, n) <+ 0.0;
  end
endmodule
