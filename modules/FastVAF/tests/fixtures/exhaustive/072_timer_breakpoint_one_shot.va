// §5.10.5 the ONE-SHOT form: "if period is not specified, or is not greater
// than zero, only a single event is scheduled". So `nextBreakpoint` has exactly
// one breakpoint to offer and must answer `none` for every `t` at or after it —
// re-offering the fire time forever would pin modules/analysis/src/tran at 3n.
//
//   t = 0     -> 3n
//   t = 1n    -> 3n
//   t = 3n    EXACTLY ON the fire time -> none (not 3n)
//   t = 4n    past it                  -> none
//
// Both control arguments are literals here, so the emitted function must take
// `_: *const Model` — an unused `model` parameter is a hard error in Zig, and
// this is the fixture that would catch the emitter naming it unconditionally.
// (071 is the mirror case: parameters, so `model` IS read.)
//
//! bias V(p) = 0
//! time 0, 1n, 3n, 4n
//! analysis tran
//! print none
`include "check.vh"
module ex072_timer_one_shot(p);
  inout p;
  electrical p;
  integer fired;
  analog begin
    @(timer(3n, 0.0)) fired = fired + 1;
    // §4.5.2 the flag latched on the step accepted at 3n is read one point later.
    `CHECKI("the one-shot fires exactly once, and never again", fired,
            ($abstime < 3.5n) ? 0 : 1);
    I(p) <+ 0.0;
  end
endmodule
