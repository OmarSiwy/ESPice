// §3.4 parameters: defaults, overrides, §3.4.5 localparam, §3.4.7 aliasparam,
// and §9.19 $param_given. The `//!` line overrides `g` and leaves `k` alone, so
// the transcript distinguishes "explicitly given" from "took its default".
//
//! param g = 7m
//! print none
`include "check.vh"
module ex100_parameters(p, n);
  inout p, n;
  electrical p, n;
  parameter real g = 1m from (0:inf);
  parameter real k = 2.5;
  parameter integer count = 3 from [1:16];
  localparam real twice_k = 2.0 * 2.5;
  aliasparam gain = g;
  analog begin
    `CHECK("overridden parameter", g, 7e-3, 0.0);
    `CHECK("default parameter", k, 2.5, 0.0);
    `CHECKI("integer parameter", count, 3);
    `CHECK("localparam folds at compile time", twice_k, 5.0, 0.0);
    `CHECK("aliasparam names the same storage", gain, g, 0.0);
    `CHECKI("$param_given on an override", $param_given(g), 1);
    `CHECKI("$param_given on a default", $param_given(k), 0);
    I(p, n) <+ 0.0;
  end
endmodule
