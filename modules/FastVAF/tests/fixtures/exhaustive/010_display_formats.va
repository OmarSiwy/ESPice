// §9.4.2/§9.4.3 display formats: every conversion FastVAF translates, plus the
// width/precision/escape forms. This fixture is about the TRANSCRIPT, not the
// physics, so `print none` leaves the output to $strobe alone.
//
//! print none
module ex010_display_formats(p, n);
  inout p, n;
  electrical p, n;

  parameter real r = 1.5;
  parameter integer k = 42;

  analog begin
    $strobe("real  %%g  -> %g", r);
    $strobe("real  %%e  -> %e", r);
    $strobe("real  %%f  -> %f", r);
    $strobe("real  %%.3f-> %.3f", r);
    $strobe("real  %%10.4f -> [%10.4f]", r);
    $strobe("real  %%-10.4f-> [%-10.4f]", r);
    $strobe("int   %%d  -> %d", k);
    $strobe("int   %%h  -> %h", k);
    $strobe("int   %%o  -> %o", k);
    $strobe("int   %%b  -> %b", k);
    $strobe("int   %%5d -> [%5d]", k);
    $strobe("int   %%05d-> [%05d]", k);
    $strobe("str   %%s  -> %s", "hello");
    $strobe("mod   %%m  -> %m");
    $strobe("escapes-> tab[\t] nl-next quote[\"] backslash[\\]");
    $write("write does not end the line: ");
    $strobe("<- and this $strobe finished it");
    $strobe("extra operands with no conversion:", r, k);
    I(p, n) <+ 0.0;
  end
endmodule
