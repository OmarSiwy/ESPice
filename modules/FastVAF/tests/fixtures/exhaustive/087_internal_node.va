// §3.6.3 an internal net. It is a solver unknown like a port but is NOT in the
// terminal order, so `num_ports` stays 2 while `U` grows to 3 — the transcript
// shows the third unknown and the series topology's tridiagonal Jacobian.
//
//! param rs = 100, rp = 1k
//! bias V(n) = 0
//! sweep V(p) = 0, 1
`include "check.vh"
module ex087_internal_node(p, n);
  inout p, n;
  electrical p, n;
  electrical mid;
  parameter real rs = 50 from (0:inf);
  parameter real rp = 500 from (0:inf);
  analog begin
    `CHECK("series resistance", rs, 100.0, 0.0);
    `CHECK("shunt resistance", rp, 1000.0, 0.0);
    I(p, mid) <+ V(p, mid) / rs;
    I(mid, n) <+ V(mid, n) / rp;
  end
endmodule
