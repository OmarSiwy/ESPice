// §9.7.3 severity tasks. Their whole content is the message plus the severity,
// which a reader cannot recover from the text — so the generated print carries
// the level as a prefix.
//
// §9.7.1/§9.7.2 `$finish` and `$stop` stay void even here: stopping is the
// SIMULATOR's action, and this artifact is a transcript, not a solve.
//
//! print none
module ex011_severity(p, n);
  inout p, n;
  electrical p, n;
  analog begin
    $info("informational, value=%g", 1.25);
    $warning("something is unusual: %d", 7);
    $error("a diagnosed condition: %s", "bad bias");
    $fatal(1, "a fatal condition: %g", 0.5);
    $finish;
    $stop;
    I(p, n) <+ 0.0;
  end
endmodule
