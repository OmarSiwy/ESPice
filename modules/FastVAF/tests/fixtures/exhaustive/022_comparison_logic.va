// §4.2.5 relational, §4.2.6 equality, §4.2.7 logical. Every one of these
// produces an INTEGER 0 or 1 (§4.2.5), which is what lets `check.vh` make a
// verdict an operand instead of a branch.
//
//! print none
`include "check.vh"
module ex022_comparison_logic(p, n);
  inout p, n;
  electrical p, n;
  analog begin
    `CHECKI("lt true", 1.0 < 2.0, 1);
    `CHECKI("lt false", 2.0 < 1.0, 0);
    `CHECKI("le at equality", 2.0 <= 2.0, 1);
    `CHECKI("gt", 3 > 2, 1);
    `CHECKI("ge at equality", 2 >= 2, 1);
    `CHECKI("eq real", 0.5 == 0.5, 1);
    `CHECKI("ne real", 0.5 != 0.25, 1);
    `CHECKI("logical and", (1 < 2) && (3 < 4), 1);
    `CHECKI("logical and short of true", (1 < 2) && (4 < 3), 0);
    `CHECKI("logical or", (2 < 1) || (3 < 4), 1);
    `CHECKI("logical not of zero", !0, 1);
    `CHECKI("logical not of nonzero", !5, 0);
    // §4.2.7: a nonzero REAL is true, and the result is still an integer.
    `CHECKI("real as condition", (0.5 && 1), 1);
    `CHECKI("zero real as condition", (0.0 && 1), 0);
    I(p, n) <+ 0.0;
  end
endmodule
