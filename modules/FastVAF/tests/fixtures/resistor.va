// Simple resistor model
`include "constants.vams"
`include "disciplines.vams"

module resistor(p, n);
    inout p, n;
    electrical p, n;
    parameter real R = 1.0k from (0:inf);

    analog begin
        I(p, n) <+ V(p, n) / R;
    end
endmodule
