// Conformance: negative — Bad expression
// EXPECT: parse_error
`include "disciplines.vams"
module conf_neg_expr(p, n);
    inout p, n;
    electrical p, n;
    analog
        I(p, n) <+ * V(p, n);
endmodule
