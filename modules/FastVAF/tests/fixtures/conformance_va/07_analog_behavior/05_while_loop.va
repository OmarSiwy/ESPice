// Conformance: 5.9.1 — While loop
// EXPECT: compile_ok
`include "disciplines.vams"
module conf_ab_while(p, n);
    inout p, n;
    electrical p, n;
    integer i;
    real sum;
    analog begin
        sum = 0;
        i = 0;
        while (i < 10) begin
            sum = sum + i;
            i = i + 1;
        end
        I(p, n) <+ sum;
    end
endmodule
