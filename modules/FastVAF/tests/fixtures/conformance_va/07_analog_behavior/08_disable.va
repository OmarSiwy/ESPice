// Conformance: 5.3.2 — Disable statement
// EXPECT: compile_ok
`include "disciplines.vams"
module conf_ab_disable(p, n);
    inout p, n;
    electrical p, n;
    integer i;
    real sum;
    analog begin
        begin : search
            sum = 0;
            for (i = 0; i < 100; i = i + 1) begin
                sum = sum + i;
                if (sum > 50)
                    disable search;
            end
        end
        I(p, n) <+ sum;
    end
endmodule
