// Conformance: 5.9.2 — For loop
// EXPECT: compile_ok
`include "disciplines.vams"
module conf_ab_for(p, n);
    inout p, n;
    electrical p, n;
    integer i;
    real sum;
    analog begin
        sum = 0;
        for (i = 0; i < 10; i = i + 1)
            sum = sum + i;
        I(p, n) <+ sum;
    end
endmodule
