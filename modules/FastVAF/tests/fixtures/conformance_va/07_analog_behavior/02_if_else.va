// Conformance: 5.8.1 — if-else-if statement
// EXPECT: compile_ok
`include "disciplines.vams"
module conf_ab_ifelse(p, n);
    inout p, n;
    electrical p, n;
    parameter real vth = 0.5;
    analog begin
        if (V(p, n) > vth)
            I(p, n) <+ (V(p, n) - vth) / 100.0;
        else if (V(p, n) < -vth)
            I(p, n) <+ (V(p, n) + vth) / 100.0;
        else
            I(p, n) <+ 0;
    end
endmodule
