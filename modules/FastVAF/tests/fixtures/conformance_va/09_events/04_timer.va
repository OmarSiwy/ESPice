// Conformance: 5.10.3 — timer() event
// EXPECT: compile_ok
`include "disciplines.vams"
module conf_ev_timer(p, n);
    inout p, n;
    electrical p, n;
    integer toggle;
    analog begin
        @(timer(0, 1.0e-6))
            toggle = !toggle;
        I(p, n) <+ toggle ? V(p, n) / 1.0k : 0;
    end
endmodule
