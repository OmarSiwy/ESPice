// Conformance: Real device — Voltage-dependent capacitance (varactor)
// Exercises: ddt, junction cap model, parameter ranges, $vt
// EXPECT: compile_ok
`include "disciplines.vams"
module varactor(a, c);
    inout a, c;
    electrical a, c;

    parameter real C0  = 1.0p   from (0:inf);
    parameter real VJ  = 0.7    from (0:inf);
    parameter real M   = 0.5    from [0:1);
    parameter real FC  = 0.5    from [0:1);
    parameter real RS  = 0.0    from [0:inf);

    analog begin
        real v, cap, q;
        real f2, f3;
        v = V(a, c);
        if (v < FC * VJ)
            cap = C0 * pow(1.0 - v / VJ, -M);
        else begin
            f2 = pow(1.0 - FC, 1.0 + M);
            f3 = 1.0 - FC * (1.0 + M);
            cap = C0 / f2 * (f3 + M * v / VJ);
        end
        I(a, c) <+ ddt(cap * v);
        if (RS > 0)
            I(a, c) <+ white_noise(4.0 * 1.3806503e-23 * $temperature / RS, "thermal");
    end
endmodule
