// Conformance: 4.5.13 — Limited exponential
// EXPECT: compile_ok
`include "disciplines.vams"
module conf_op_limexp(p, n);
    inout p, n;
    electrical p, n;
    parameter real IS = 1e-14;
    analog
        I(p, n) <+ IS * (limexp(V(p, n) / $vt) - 1);
endmodule
