// Conformance: 4.5.5 — Circular integrator idtmod
// EXPECT: compile_ok
`include "disciplines.vams"
module conf_op_idtmod(p, n);
    inout p, n;
    electrical p, n;
    parameter real fc = 1.0e6;
    real phase;
    analog begin
        phase = idtmod(fc, 0, 1, 0);
        V(p, n) <+ sin(2.0 * 3.14159265 * phase);
    end
endmodule
