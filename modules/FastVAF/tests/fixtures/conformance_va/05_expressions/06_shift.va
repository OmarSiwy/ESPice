// Conformance: 4.2.11 — Shift operators
// EXPECT: compile_ok
`include "disciplines.vams"
module conf_expr_shift(p, n);
    inout p, n;
    electrical p, n;
    integer a, r;
    analog begin
        a = 1;
        r = a << 2;
        r = a >> 1;
        I(p, n) <+ r;
    end
endmodule
