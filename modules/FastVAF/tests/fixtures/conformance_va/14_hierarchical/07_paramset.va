// Conformance: 6.4 — Paramset declarations
// EXPECT: compile_ok
`include "disciplines.vams"
module resistor(p, n);
    inout p, n;
    electrical p, n;
    parameter real r = 1.0k from (0:inf);
    analog
        I(p, n) <+ V(p, n) / r;
endmodule

paramset my_resistor resistor;
    parameter real r = 2.2k from (0:inf);
    .r = r;
endparamset
