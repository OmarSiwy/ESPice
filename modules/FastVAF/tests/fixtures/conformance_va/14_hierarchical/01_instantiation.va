// Conformance: 6.2.2 — Module instantiation
// EXPECT: compile_ok
`include "disciplines.vams"
module resistor(p, n);
    inout p, n;
    electrical p, n;
    parameter real r = 1.0k;
    analog
        I(p, n) <+ V(p, n) / r;
endmodule

module conf_hier_inst(a, b);
    inout a, b;
    electrical a, b;
    resistor #(.r(2.0k)) r1(a, b);
endmodule
