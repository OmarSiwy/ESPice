// Conformance: 6.5.5 — Connecting ports by name
// EXPECT: compile_ok
`include "disciplines.vams"
module resistor(p, n);
    inout p, n;
    electrical p, n;
    parameter real r = 1.0k;
    analog
        I(p, n) <+ V(p, n) / r;
endmodule

module conf_hier_named(a, b);
    inout a, b;
    electrical a, b;
    resistor #(.r(500)) r1(.p(a), .n(b));
endmodule
