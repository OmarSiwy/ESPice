// Conformance: 3.6.3 — Net declarations
// EXPECT: compile_ok
`include "disciplines.vams"
module conf_mod_nets(p, n);
    inout p, n;
    electrical p, n;
    electrical mid;
    analog begin
        I(p, mid) <+ V(p, mid) / 1.0k;
        I(mid, n) <+ V(mid, n) / 2.0k;
    end
endmodule
