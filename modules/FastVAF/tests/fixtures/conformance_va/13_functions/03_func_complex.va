// Conformance: 4.7 — Complex analog function with locals and branching
// EXPECT: compile_ok
`include "disciplines.vams"
module conf_func_complex(p, n);
    inout p, n;
    electrical p, n;
    parameter real vth = 0.7;

    analog function real soft_clip;
        input x, lim;
        real x, lim;
        real ax;
        begin
            ax = abs(x);
            if (ax < lim)
                soft_clip = x;
            else
                soft_clip = lim * (x / ax);
        end
    endfunction

    analog function real smooth_abs;
        input x, delta;
        real x, delta;
        smooth_abs = sqrt(x * x + delta * delta);
    endfunction

    analog
        I(p, n) <+ soft_clip(V(p, n) - vth, 5.0) / 1.0k
                  + smooth_abs(V(p, n), 1.0e-6) * 1.0e-9;
endmodule
