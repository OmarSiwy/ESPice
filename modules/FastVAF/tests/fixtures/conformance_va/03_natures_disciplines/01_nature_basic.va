// Conformance: 3.6.1 — Basic nature
// EXPECT: compile_ok
nature Voltage;
    units = "V";
    access = V;
    abstol = 1u;
endnature

nature Current;
    units = "A";
    access = I;
    abstol = 1p;
endnature

discipline electrical;
    potential Voltage;
    flow Current;
enddiscipline

module conf_nat_basic(p, n);
    inout p, n;
    electrical p, n;
    analog
        I(p, n) <+ V(p, n);
endmodule
