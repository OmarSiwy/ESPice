// Conformance: 3.6.2 — Thermal discipline
// EXPECT: compile_ok
`include "disciplines.vams"

module conf_thermal(p, n, t);
    inout p, n, t;
    electrical p, n;
    thermal t;
    parameter real rth = 100.0;
    analog begin
        I(p, n) <+ V(p, n) / 1.0k;
        Pwr(t) <+ V(p, n) * I(p, n);
    end
endmodule
