// Conformance: 9.12 — $vt and $vt(temp)
// EXPECT: compile_ok
`include "disciplines.vams"
module conf_sys_vt(p, n);
    inout p, n;
    electrical p, n;
    real vt_default, vt_custom;
    analog begin
        vt_default = $vt;
        vt_custom = $vt($temperature + 10);
        I(p, n) <+ V(p, n) / vt_default;
    end
endmodule
