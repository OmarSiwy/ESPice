// Conformance: 9.7 — $abstime
// EXPECT: compile_ok
`include "disciplines.vams"
module conf_sys_abstime(p, n);
    inout p, n;
    electrical p, n;
    parameter real freq = 1.0e6;
    analog
        V(p, n) <+ sin(2.0 * 3.14159265 * freq * $abstime);
endmodule
