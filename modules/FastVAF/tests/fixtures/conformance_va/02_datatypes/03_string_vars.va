// Conformance: 3.3 — String data type
// EXPECT: compile_ok
`include "disciplines.vams"
module conf_dt_string(p, n);
    inout p, n;
    electrical p, n;
    string s;
    string s2 = "hello";
    parameter string mode = "default";
    real val;
    analog begin
        if (mode == "default")
            val = 1.0;
        else
            val = 2.0;
        I(p, n) <+ val;
    end
endmodule
