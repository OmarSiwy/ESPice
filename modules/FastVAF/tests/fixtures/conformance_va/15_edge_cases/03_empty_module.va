// Conformance: edge — Empty module
// EXPECT: compile_ok
module conf_edge_empty;
endmodule
