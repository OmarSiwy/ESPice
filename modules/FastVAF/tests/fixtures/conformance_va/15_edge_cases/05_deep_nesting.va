// Conformance: edge — Deep nesting
// EXPECT: compile_ok
`include "disciplines.vams"
module conf_edge_deep(p, n);
    inout p, n;
    electrical p, n;
    real r;
    analog begin
        if (V(p,n) > 0) begin
            if (V(p,n) > 1) begin
                if (V(p,n) > 2) begin
                    if (V(p,n) > 3) begin
                        if (V(p,n) > 4) begin
                            r = 5.0;
                        end else r = 4.0;
                    end else r = 3.0;
                end else r = 2.0;
            end else r = 1.0;
        end else r = 0.0;
        I(p, n) <+ r;
    end
endmodule
