// Conformance: 2.6.2 — Real constants
// EXPECT: compile_ok
`include "disciplines.vams"
module conf_lex_reals(p, n);
    inout p, n;
    electrical p, n;
    parameter real r1 = 3.14;
    parameter real r2 = 0.1;
    parameter real r3 = 1.2E12;
    parameter real r4 = 1.30e-2;
    parameter real r5 = 23E10;
    parameter real si_T = 1.0T;
    parameter real si_G = 2.0G;
    parameter real si_M = 3.0M;
    parameter real si_K = 4.0K;
    parameter real si_k = 5.0k;
    parameter real si_m = 6.0m;
    parameter real si_u = 7.0u;
    parameter real si_n = 8.0n;
    parameter real si_p = 9.0p;
    parameter real si_f = 10.0f;
    parameter real si_a = 11.0a;
    analog
        I(p, n) <+ r1 + r2 + r3 + r4 + r5;
endmodule
