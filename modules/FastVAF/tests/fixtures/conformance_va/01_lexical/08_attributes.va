// Conformance: 2.9 — Attributes
// EXPECT: compile_ok
`include "disciplines.vams"
module conf_lex_attributes(p, n);
    inout p, n;
    electrical p, n;
    (* desc="Resistance value", units="Ohms" *)
    parameter real R = 1.0k from (0:inf);
    (* desc="output variable", units="A" *)
    real iout;
    analog begin
        iout = V(p, n) / R;
        I(p, n) <+ iout;
    end
endmodule
