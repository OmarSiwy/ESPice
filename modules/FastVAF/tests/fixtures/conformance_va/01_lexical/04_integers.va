// Conformance: 2.6.1 — Integer constants
// EXPECT: compile_ok
`include "disciplines.vams"
module conf_lex_integers(p, n);
    inout p, n;
    electrical p, n;
    parameter integer dec = 42;
    parameter integer with_under = 1_000_000;
    integer hex_val, bin_val, oct_val, dec_based;
    analog begin
        hex_val = 8'hFF;
        bin_val = 4'b1010;
        oct_val = 8'o77;
        dec_based = 8'd255;
        I(p, n) <+ dec + hex_val + bin_val + oct_val + dec_based + with_under;
    end
endmodule
