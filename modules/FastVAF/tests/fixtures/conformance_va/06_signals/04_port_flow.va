// Conformance: 5.4.3 — Port flow access I(<port>)
// EXPECT: compile_ok
`include "disciplines.vams"
module conf_sig_portflow(a, b);
    inout a, b;
    electrical a, b;
    parameter real imax = 1.0;
    analog begin
        I(a, b) <+ V(a, b) / 1.0k;
        if (I(<a>) > imax)
            $strobe("overcurrent!");
    end
endmodule
