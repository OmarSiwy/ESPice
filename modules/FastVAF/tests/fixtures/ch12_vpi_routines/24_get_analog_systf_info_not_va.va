// EXPECT: error
module ch12_atomic_get_analog_systf_info(p, n);
  inout p, n; electrical p, n;
  analog I(p,n) <+ vpi_get_analog_systf_info(0);
endmodule
