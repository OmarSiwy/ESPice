// EXPECT: error
module ch12_mcd_not_va(p, n);
  inout p, n; electrical p, n;
  analog I(p,n) <+ vpi_mcd_open(0);
endmodule
