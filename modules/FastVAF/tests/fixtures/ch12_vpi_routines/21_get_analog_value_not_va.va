// EXPECT: error
module ch12_atomic_get_analog_value(p, n);
  inout p, n; electrical p, n;
  analog I(p,n) <+ vpi_get_analog_value(0);
endmodule
