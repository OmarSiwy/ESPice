// The engine prepends annex D (constants.vams / disciplines.vams), which already
// defines CONSTANTS_VAMS and DISCIPLINES_VAMS, so this fixture carries its own
// include guard instead of the standard one -- otherwise its body is skipped.
`ifdef ANNEX_D_MATHEMATICAL_CONSTANTS
`else
`define ANNEX_D_MATHEMATICAL_CONSTANTS 1
`define M_E 2.7182818284590452354
`define M_LOG2E 1.4426950408889634074
`define M_LOG10E 0.43429448190325182765
`define M_LN2 0.69314718055994530942
`define M_LN10 2.30258509299404568402
`define M_PI 3.14159265358979323846
`define M_TWO_PI 6.28318530717958647693
`define M_PI_2 1.57079632679489661923
`define M_PI_4 0.78539816339744830962
`define M_1_PI 0.31830988618379067154
`define M_2_PI 0.63661977236758134308
`define M_2_SQRTPI 1.12837916709551257390
`define M_SQRT2 1.41421356237309504880
`define M_SQRT1_2 0.70710678118654752440
module annex_d_math(p);
  inout p; electrical p;
  analog I(p) <+ `M_E + `M_LOG2E + `M_LOG10E + `M_LN2 + `M_LN10
      + `M_PI + `M_TWO_PI + `M_PI_2 + `M_PI_4 + `M_1_PI + `M_2_PI
      + `M_2_SQRTPI + `M_SQRT2 + `M_SQRT1_2 + 0.0*V(p);
endmodule
`endif
