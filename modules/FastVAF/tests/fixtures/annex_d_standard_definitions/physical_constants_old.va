`define PHYSICAL_CONSTANTS_OLD 1
// NIST2010 is also set: OLD has higher priority in the normative chain.
`define PHYSICAL_CONSTANTS_NIST2010 1
`include "physical_constants_select.vh"
module annex_d_old(p); inout p; electrical p; analog I(p)<+`P_Q+`P_K+`P_H+`P_EPS0+`P_U0+0.0*V(p); endmodule
