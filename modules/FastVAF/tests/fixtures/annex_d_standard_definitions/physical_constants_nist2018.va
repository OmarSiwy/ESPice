`define PHYSICAL_CONSTANTS_NIST2018 1
// Define every lower-priority selector too: NIST2018 must still win.
`define PHYSICAL_CONSTANTS_SPICE 1
`define PHYSICAL_CONSTANTS_OLD 1
`define PHYSICAL_CONSTANTS_NIST2010 1
`include "physical_constants_select.vh"
module annex_d_nist2018(p);
  inout p; electrical p;
  analog I(p) <+ `P_Q + `P_K + `P_H + `P_EPS0 + `P_U0 + 0.0*V(p);
endmodule
