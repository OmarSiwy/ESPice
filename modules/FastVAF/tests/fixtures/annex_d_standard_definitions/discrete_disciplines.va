discipline logic_disc;
  domain discrete;
enddiscipline
discipline ddiscrete;
  domain discrete;
enddiscipline
module annex_d_discrete;
  electrical p;
  analog I(p) <+ V(p);
endmodule
