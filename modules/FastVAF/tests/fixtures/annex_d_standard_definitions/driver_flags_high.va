`define DRIVER_SDF 32'b00000100000
`define DRIVER_NODELETE 32'b00001000000
`define DRIVER_NOPREEMPT 32'b00010000000
`define DRIVER_KERNEL 32'b00100000000
`define DRIVER_WOR 32'b01000000000
`define DRIVER_WAND 32'b10000000000
module annex_d_driver_high(p);
  inout p; electrical p; integer flags;
  analog begin flags = `DRIVER_SDF | `DRIVER_NODELETE | `DRIVER_NOPREEMPT | `DRIVER_KERNEL | `DRIVER_WOR | `DRIVER_WAND; I(p) <+ flags + 0.0*V(p); end
endmodule
