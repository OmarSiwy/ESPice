module Module(p, n);
    inout p, n;
    electrical p, n;
    real Analog;

    analog begin
        Analog = 1.0;
        I(p, n) <+ Analog;
    end
endmodule
