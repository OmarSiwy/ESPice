module annex_c_no_discipline(p); inout p; analog I(p)<+V(p); endmodule
