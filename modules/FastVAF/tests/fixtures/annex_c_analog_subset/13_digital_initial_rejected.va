// EXPECT: error
module annex_c_digital_initial_rejected;
    integer state;
    initial state = 1;
endmodule
