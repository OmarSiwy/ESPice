// Conformance: 9.16 — $bound_step
// EXPECT: compile_ok
`include "disciplines.vams"
module conf_sys_boundstep(p, n);
    inout p, n;
    electrical p, n;
    parameter real max_step = 1.0n;
    analog begin
        $bound_step(max_step);
        I(p, n) <+ V(p, n) / 1.0k;
    end
endmodule
