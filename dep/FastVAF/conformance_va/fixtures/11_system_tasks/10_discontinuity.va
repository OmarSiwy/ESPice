// Conformance: 9.13 — $discontinuity
// EXPECT: compile_ok
`include "disciplines.vams"
module conf_sys_discont(p, n);
    inout p, n;
    electrical p, n;
    parameter real vth = 0.5;
    analog begin
        if (V(p, n) > vth) begin
            $discontinuity(0);
            I(p, n) <+ (V(p, n) - vth) / 100.0;
        end else
            I(p, n) <+ 0;
    end
endmodule
