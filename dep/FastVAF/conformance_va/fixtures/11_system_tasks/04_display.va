// Conformance: 9.2 — $display, $strobe, $write
// EXPECT: compile_ok
`include "disciplines.vams"
module conf_sys_display(p, n);
    inout p, n;
    electrical p, n;
    analog begin
        I(p, n) <+ V(p, n) / 1.0k;
        @(initial_step) begin
            $display("module initialized");
            $strobe("voltage = %g", V(p, n));
            $write("current = %g\n", I(p, n));
        end
    end
endmodule
