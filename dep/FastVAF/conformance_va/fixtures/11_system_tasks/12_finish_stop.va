// Conformance: 9.4 — $finish, $stop
// EXPECT: compile_ok
`include "disciplines.vams"
module conf_sys_finstop(p, n);
    inout p, n;
    electrical p, n;
    analog begin
        I(p, n) <+ V(p, n) / 1.0k;
        if (V(p, n) > 1000.0)
            $finish;
    end
endmodule
