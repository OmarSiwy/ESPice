// Conformance: 9.4 — $warning, $error, $fatal, $info
// EXPECT: compile_ok
`include "disciplines.vams"
module conf_sys_severity(p, n);
    inout p, n;
    electrical p, n;
    parameter real R = 1.0k from (0:inf);
    analog begin
        if (V(p, n) > 10.0)
            $warning("voltage exceeds 10V");
        if (V(p, n) > 100.0)
            $error("voltage exceeds safe limit");
        $info("module running");
        I(p, n) <+ V(p, n) / R;
    end
endmodule
