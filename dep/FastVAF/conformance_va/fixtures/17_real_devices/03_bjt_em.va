// Conformance: Real device — Ebers-Moll BJT (NPN)
// Exercises: 3 terminals, internal node, multiple branches, limexp,
//            $temperature, $vt, noise, ddt, conditional contrib
// EXPECT: compile_ok
`include "disciplines.vams"
module bjt_em(c, b, e);
    inout c, b, e;
    electrical c, b, e;
    electrical bi;

    parameter real IS  = 1.0e-16  from (0:inf);
    parameter real BF  = 100.0    from (0.1:inf);
    parameter real BR  = 1.0      from (0.1:inf);
    parameter real NF  = 1.0      from (0.5:5];
    parameter real NR  = 1.0      from (0.5:5];
    parameter real RB  = 0.0      from [0:inf);
    parameter real VAF = 0.0      from [0:inf);
    parameter real VAR = 0.0      from [0:inf);
    parameter real TF  = 0.0      from [0:inf);
    parameter real TR  = 0.0      from [0:inf);
    parameter real CJE = 0.0      from [0:inf);
    parameter real VJE = 0.75     from (0:inf);
    parameter real MJE = 0.33     from [0:1);
    parameter real CJC = 0.0      from [0:inf);
    parameter real VJC = 0.75     from (0:inf);
    parameter real MJC = 0.33     from [0:1);
    parameter real KF  = 0.0      from [0:inf);
    parameter real AF  = 1.0;

    real vbe, vbc, ic, ib, iff, ir, qbe, qbc;
    real vt;

    analog begin
        vt = $vt;
        vbe = V(bi, e);
        vbc = V(bi, c);

        iff = IS * (limexp(vbe / (NF * vt)) - 1.0);
        ir  = IS * (limexp(vbc / (NR * vt)) - 1.0);

        if (VAF > 0.0)
            iff = iff * (1.0 + V(c, e) / VAF);
        if (VAR > 0.0)
            ir = ir * (1.0 + V(e, c) / VAR);

        ic = iff - ir;
        ib = iff / BF + ir / BR;

        I(c, e) <+ ic;
        I(bi, e) <+ ib;

        if (RB > 0)
            I(b, bi) <+ V(b, bi) / RB;
        else
            V(b, bi) <+ 0.0;

        if (CJE > 0) begin
            if (vbe < 0.5 * VJE)
                qbe = CJE * VJE / (1.0 - MJE) * (1.0 - pow(1.0 - vbe / VJE, 1.0 - MJE));
            else
                qbe = CJE * vbe;
            I(bi, e) <+ ddt(qbe);
        end
        if (TF > 0)
            I(bi, e) <+ ddt(TF * iff);

        if (CJC > 0) begin
            if (vbc < 0.5 * VJC)
                qbc = CJC * VJC / (1.0 - MJC) * (1.0 - pow(1.0 - vbc / VJC, 1.0 - MJC));
            else
                qbc = CJC * vbc;
            I(bi, c) <+ ddt(qbc);
        end
        if (TR > 0)
            I(bi, c) <+ ddt(TR * ir);

        I(bi, e) <+ white_noise(2.0 * 1.6021766e-19 * abs(ib), "ib_shot");
        I(c, e)  <+ white_noise(2.0 * 1.6021766e-19 * abs(ic), "ic_shot");
        if (RB > 0)
            I(b, bi) <+ white_noise(4.0 * 1.3806503e-23 * $temperature / RB, "rb_thermal");
        I(bi, e) <+ flicker_noise(KF * pow(abs(ib), AF), 1.0, "flicker");
    end
endmodule
