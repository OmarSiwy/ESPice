// Conformance: Real device — RLC series (uses ddt + idt together)
// Exercises: ddt, idt, multiple contributions, parameter ranges
// EXPECT: compile_ok
`include "disciplines.vams"
module rlc_series(p, n);
    inout p, n;
    electrical p, n;

    parameter real R = 50.0  from (0:inf);
    parameter real L = 1.0n  from (0:inf);
    parameter real C = 1.0p  from (0:inf);

    analog begin
        V(p, n) <+ R * I(p, n);
        V(p, n) <+ L * ddt(I(p, n));
        V(p, n) <+ idt(I(p, n), 0.0) / C;
    end
endmodule
