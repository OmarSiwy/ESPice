// Conformance: Real device — Level 1 MOSFET (Shichman-Hodges)
// Exercises: 4 terminals, internal nodes, $param_given, $temperature,
//            conditional regions, ddt, white_noise, flicker_noise
// EXPECT: compile_ok
`include "disciplines.vams"
module mosfet_l1(d, g, s, b);
    inout d, g, s, b;
    electrical d, g, s, b;
    electrical di, si;

    parameter integer TYPE = 1     from [-1:1] exclude 0;
    parameter real VTO    = 0.7    from (-inf:inf);
    parameter real KP     = 2.0e-5 from (0:inf);
    parameter real GAMMA  = 0.0    from [0:inf);
    parameter real PHI    = 0.6    from (0:inf);
    parameter real LAMBDA = 0.0    from [0:inf);
    parameter real RD     = 0.0    from [0:inf);
    parameter real RS     = 0.0    from [0:inf);
    parameter real CBD    = 0.0    from [0:inf);
    parameter real CBS    = 0.0    from [0:inf);
    parameter real L      = 1.0u   from (0:inf);
    parameter real W      = 1.0u   from (0:inf);
    parameter real TOX    = 1.0e-8 from (0:inf);
    parameter real KF     = 0.0    from [0:inf);
    parameter real AF     = 1.0;
    parameter real TNOM   = 27.0;

    real vgs, vds, vbs, vth, ids;
    real beta, vdsat;

    analog begin
        vgs = TYPE * V(g, si);
        vds = TYPE * V(di, si);
        vbs = TYPE * V(b, si);

        if (GAMMA > 0 && PHI - vbs > 0)
            vth = VTO + GAMMA * (sqrt(PHI - vbs) - sqrt(PHI));
        else
            vth = VTO;

        beta = KP * W / L;

        if (vgs <= vth) begin
            ids = 0;
        end else begin
            vdsat = vgs - vth;
            if (vds < vdsat)
                ids = beta * (vds * (vgs - vth) - 0.5 * vds * vds) * (1.0 + LAMBDA * vds);
            else
                ids = 0.5 * beta * vdsat * vdsat * (1.0 + LAMBDA * vds);
        end

        I(di, si) <+ TYPE * ids;

        if (RD > 0)
            I(d, di) <+ V(d, di) / RD;
        else
            V(d, di) <+ 0.0;
        if (RS > 0)
            I(s, si) <+ V(s, si) / RS;
        else
            V(s, si) <+ 0.0;

        if (CBD > 0)
            I(b, di) <+ ddt(CBD * V(b, di));
        if (CBS > 0)
            I(b, si) <+ ddt(CBS * V(b, si));

        I(di, si) <+ white_noise(4.0 * 1.3806503e-23 * $temperature * (2.0 / 3.0) * beta * abs(vgs - vth), "channel");
        if (KF > 0 && ids > 0)
            I(di, si) <+ flicker_noise(KF * ids * ids / (W * L * 8.854e-12 / TOX), AF, "flicker");
    end
endmodule
