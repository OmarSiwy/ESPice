// Conformance: Real device — Resistor with temperature coefficients
// Exercises: $temperature, parameter ranges, conditional, white_noise
// EXPECT: compile_ok
`include "disciplines.vams"
module resistor_tc(p, n);
    inout p, n;
    electrical p, n;

    parameter real R    = 1.0k   from (0:inf);
    parameter real TC1  = 0.0;
    parameter real TC2  = 0.0;
    parameter real TNOM = 27.0;

    analog begin
        real dt, reff;
        dt = $temperature - (TNOM + 273.15);
        reff = R * (1.0 + TC1 * dt + TC2 * dt * dt);
        if (reff < 1.0e-3)
            reff = 1.0e-3;
        I(p, n) <+ V(p, n) / reff;
        I(p, n) <+ white_noise(4.0 * 1.3806503e-23 * $temperature / reff, "thermal");
    end
endmodule
