// Conformance: 4.5.8 — Transition filter
// EXPECT: compile_ok
`include "disciplines.vams"
module conf_op_transition(out, in);
    input in;
    output out;
    electrical out, in;
    parameter real td = 0, tr = 1n, tf = 1n;
    analog
        V(out) <+ transition(V(in) > 0.5 ? 1.0 : 0.0, td, tr, tf);
endmodule
