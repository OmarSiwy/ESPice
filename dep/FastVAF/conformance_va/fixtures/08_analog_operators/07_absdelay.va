// Conformance: 4.5.7 — Absolute delay
// EXPECT: compile_ok
`include "disciplines.vams"
module conf_op_absdelay(p, n);
    inout p, n;
    electrical p, n;
    parameter real td = 1.0n;
    analog
        V(p, n) <+ absdelay(V(p, n), td);
endmodule
