// Conformance: 4.7 — User-defined analog function
// EXPECT: compile_ok
`include "disciplines.vams"
module conf_func_basic(p, n);
    inout p, n;
    electrical p, n;
    analog function real square;
        input x;
        real x;
        square = x * x;
    endfunction
    analog
        I(p, n) <+ square(V(p, n));
endmodule
