// Conformance: 4.7.1 — Function with multiple arguments
// EXPECT: compile_ok
`include "disciplines.vams"
module conf_func_args(p, n);
    inout p, n;
    electrical p, n;
    analog function real clamp;
        input val, lo, hi;
        real val, lo, hi;
        clamp = (val < lo) ? lo : ((val > hi) ? hi : val);
    endfunction
    analog
        I(p, n) <+ clamp(V(p, n), -1.0, 1.0);
endmodule
