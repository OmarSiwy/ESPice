// Conformance: 5.10.3 — above() event
// EXPECT: compile_ok
`include "disciplines.vams"
module conf_ev_above(p, n);
    inout p, n;
    electrical p, n;
    parameter real vth = 1.0;
    integer exceeded;
    analog begin
        @(above(V(p, n) - vth))
            exceeded = 1;
        I(p, n) <+ V(p, n) / 1.0k;
    end
endmodule
