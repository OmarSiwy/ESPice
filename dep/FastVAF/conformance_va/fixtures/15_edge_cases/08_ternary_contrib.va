// Conformance: 4.1.13, 5.5.2 — Ternary expression inside contribution
// EXPECT: compile_ok
`include "disciplines.vams"
module conf_ec_ternary_contrib(p, n);
    inout p, n;
    electrical p, n;
    parameter real roff = 1.0G;
    parameter real ron = 1.0;
    parameter real vth = 0.5;
    analog
        I(p, n) <+ V(p, n) / ((V(p, n) > vth) ? ron : roff);
endmodule
