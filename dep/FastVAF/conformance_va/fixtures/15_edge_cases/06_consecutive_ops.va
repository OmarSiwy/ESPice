// Conformance: edge — Consecutive/ambiguous operators
// EXPECT: compile_ok
`include "disciplines.vams"
module conf_edge_ops(p, n);
    inout p, n;
    electrical p, n;
    real a, b, r;
    analog begin
        a = 5.0; b = 3.0;
        r = a - -b;
        r = a + +b;
        r = a * -b;
        r = -a * -b;
        I(p, n) <+ r;
    end
endmodule
