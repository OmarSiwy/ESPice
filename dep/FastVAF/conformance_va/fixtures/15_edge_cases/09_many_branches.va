// Conformance: 3.5 — Module with many branches and nodes
// EXPECT: compile_ok
`include "disciplines.vams"
module conf_ec_many_branches(a, b, c, d);
    inout a, b, c, d;
    electrical a, b, c, d;
    branch (a, b) br_ab;
    branch (b, c) br_bc;
    branch (c, d) br_cd;
    branch (a, d) br_ad;
    parameter real r = 1.0k;
    analog begin
        I(br_ab) <+ V(br_ab) / r;
        I(br_bc) <+ V(br_bc) / r;
        I(br_cd) <+ V(br_cd) / r;
        I(br_ad) <+ V(br_ad) / r;
    end
endmodule
