// Conformance: 3.5, 4.4 — Internal (hidden) nodes
// EXPECT: compile_ok
`include "disciplines.vams"
module conf_ec_internal(p, n);
    inout p, n;
    electrical p, n;
    electrical mid;
    parameter real r1 = 1.0k;
    parameter real r2 = 1.0k;
    analog begin
        I(p, mid) <+ V(p, mid) / r1;
        I(mid, n) <+ V(mid, n) / r2;
    end
endmodule
