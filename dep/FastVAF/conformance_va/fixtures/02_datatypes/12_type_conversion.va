// Conformance: 4.2.1 — Type conversion
// EXPECT: compile_ok
`include "disciplines.vams"
module conf_dt_typeconv(p, n);
    inout p, n;
    electrical p, n;
    integer i;
    real r;
    analog begin
        i = 3;
        r = i + 5.0;
        r = i * 2.5;
        i = 7;
        r = 1 / 2.0;
        I(p, n) <+ r;
    end
endmodule
