// Conformance: 3.4.6 — String parameters
// EXPECT: compile_ok
`include "disciplines.vams"
module conf_dt_param_string(p, n);
    inout p, n;
    electrical p, n;
    parameter string type_sel = "NPN" from '{ "NPN", "PNP" };
    real sign;
    analog begin
        sign = (type_sel == "NPN") ? 1.0 : -1.0;
        I(p, n) <+ sign * V(p, n);
    end
endmodule
