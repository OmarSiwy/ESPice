// Conformance: 3.4.7 — Alias parameters
// EXPECT: compile_ok
`include "disciplines.vams"
module conf_dt_aliasparam(p, n);
    inout p, n;
    electrical p, n;
    parameter real dtemp = 0 from [-273.15:inf);
    aliasparam trise = dtemp;
    analog
        I(p, n) <+ V(p, n) * (1.0 + dtemp * 0.01);
endmodule
