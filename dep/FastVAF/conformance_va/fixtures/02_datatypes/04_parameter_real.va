// Conformance: 3.4.1 — Real parameters
// EXPECT: compile_ok
`include "disciplines.vams"
module conf_dt_param_real(p, n);
    inout p, n;
    electrical p, n;
    parameter real R = 1.0;
    parameter real C = 1.0e-12;
    parameter real gain = 100.0;
    analog
        I(p, n) <+ V(p, n) / R;
endmodule
