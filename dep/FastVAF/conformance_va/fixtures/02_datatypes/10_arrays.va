// Conformance: 3.2, 3.4.4 — Arrays
// EXPECT: compile_ok
`include "disciplines.vams"
module conf_dt_arrays(p, n);
    inout p, n;
    electrical p, n;
    parameter real coeffs[0:3] = '{1.0, 2.0, 3.0, 4.0};
    real vals[0:3];
    analog begin
        I(p, n) <+ 0;
    end
endmodule
