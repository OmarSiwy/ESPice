// Conformance: 4.2.9 — Bitwise operators
// EXPECT: compile_ok
`include "disciplines.vams"
module conf_expr_bitwise(p, n);
    inout p, n;
    electrical p, n;
    integer a, b, r;
    analog begin
        a = 5; b = 3;
        r = a & b;
        r = a | b;
        r = a ^ b;
        r = ~a;
        r = a ~^ b;
        r = a ^~ b;
        I(p, n) <+ r;
    end
endmodule
