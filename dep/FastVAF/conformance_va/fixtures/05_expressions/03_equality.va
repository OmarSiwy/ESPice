// Conformance: 4.2.7 — Equality operators
// EXPECT: compile_ok
`include "disciplines.vams"
module conf_expr_eq(p, n);
    inout p, n;
    electrical p, n;
    real a, b;
    integer r;
    analog begin
        a = 5.0; b = 5.0;
        r = (a == b);
        r = (a != b);
        I(p, n) <+ r;
    end
endmodule
