// Conformance: 4.3.4 — abs and sign functions
// EXPECT: compile_ok
`include "disciplines.vams"
module conf_expr_abs_sign(p, n);
    inout p, n;
    electrical p, n;
    analog begin
        real v, mag, dir;
        v = V(p, n);
        mag = abs(v);
        dir = (v >= 0) ? 1.0 : -1.0;
        I(p, n) <+ mag * dir / 1.0k;
    end
endmodule
