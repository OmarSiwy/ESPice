// Conformance: 5.6.1.2 — Multiple additive contributions
// EXPECT: compile_ok
`include "disciplines.vams"
module conf_sig_multi_contrib(p, n);
    inout p, n;
    electrical p, n;
    parameter real R = 1.0k;
    parameter real C = 1.0p;
    analog begin
        I(p, n) <+ V(p, n) / R;
        I(p, n) <+ C * ddt(V(p, n));
    end
endmodule
