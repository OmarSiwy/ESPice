// Conformance: 4.4, 5.5.1 — Voltage access V(a,b) and V(a)
// EXPECT: compile_ok
`include "disciplines.vams"
module conf_sig_voltage(a, b, c);
    inout a, b, c;
    electrical a, b, c;
    real vab, va;
    analog begin
        vab = V(a, b);
        va = V(a);
        I(a, b) <+ vab;
        I(c) <+ va;
    end
endmodule
