// Conformance: 11.2 — Nested `ifdef
// EXPECT: compile_ok
`include "disciplines.vams"
`define FEATURE_A
`define FEATURE_B

module conf_pp_nested(p, n);
    inout p, n;
    electrical p, n;
    analog begin
`ifdef FEATURE_A
    `ifdef FEATURE_B
        I(p, n) <+ V(p, n) / 1.0k;
    `else
        I(p, n) <+ V(p, n) / 2.0k;
    `endif
`else
        I(p, n) <+ 0;
`endif
    end
endmodule
