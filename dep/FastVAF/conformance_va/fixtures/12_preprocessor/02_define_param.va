// Conformance: 11.1 — Parameterized `define
// EXPECT: compile_ok
`include "disciplines.vams"
`define MAX(a, b) ((a) > (b) ? (a) : (b))
`define CLAMP(val, lo, hi) `MAX(lo, ((val) < (hi) ? (val) : (hi)))

module conf_pp_macro(p, n);
    inout p, n;
    electrical p, n;
    real v;
    analog begin
        v = `MAX(V(p, n), 0.0);
        I(p, n) <+ v / 1.0k;
    end
endmodule
