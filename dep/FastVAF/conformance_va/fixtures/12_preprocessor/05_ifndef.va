// Conformance: 11.2 — `ifndef
// EXPECT: compile_ok
`include "disciplines.vams"
`ifndef OVERRIDE_TEMP
`define TEMP 300.15
`endif

module conf_pp_ifndef(p, n);
    inout p, n;
    electrical p, n;
    analog
        I(p, n) <+ V(p, n) / `TEMP;
endmodule
