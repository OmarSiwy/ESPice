// Conformance: negative — Missing semicolon
// EXPECT: parse_error
`include "disciplines.vams"
module conf_neg_semi(p, n);
    inout p, n;
    electrical p, n
    analog
        I(p, n) <+ V(p, n);
endmodule
