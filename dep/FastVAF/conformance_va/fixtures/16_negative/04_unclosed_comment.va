// Conformance: negative — Unclosed block comment
// EXPECT: parse_error
`include "disciplines.vams"
/* This comment is never closed
module conf_neg_comment(p, n);
    inout p, n;
    electrical p, n;
    analog
        I(p, n) <+ V(p, n);
endmodule
