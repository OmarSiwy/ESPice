// Conformance: 6.5.4 — Connecting ports by ordered list
// EXPECT: compile_ok
`include "disciplines.vams"
module resistor(p, n);
    inout p, n;
    electrical p, n;
    parameter real r = 1.0k;
    analog
        I(p, n) <+ V(p, n) / r;
endmodule

module conf_hier_pos(a, b);
    inout a, b;
    electrical a, b;
    resistor r1(a, b);
endmodule
