// Conformance: 2.7 — String literals
// EXPECT: compile_ok
`include "disciplines.vams"
module conf_lex_strings(p, n);
    inout p, n;
    electrical p, n;
    parameter string s1 = "hello world";
    parameter string s2 = "tab\there";
    parameter string s3 = "newline\nhere";
    parameter string s4 = "quote\"here";
    parameter string s5 = "backslash\\here";
    parameter string s6 = "";
    analog
        I(p, n) <+ 0;
endmodule
