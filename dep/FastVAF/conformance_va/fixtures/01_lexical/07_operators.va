// Conformance: 2.5 — Operators
// EXPECT: compile_ok
`include "disciplines.vams"
module conf_lex_operators(p, n);
    inout p, n;
    electrical p, n;
    parameter real a = 5.0;
    parameter real b = 3.0;
    parameter integer ia = 5;
    parameter integer ib = 3;
    real r;
    integer ir;
    analog begin
        r = a + b;
        r = a - b;
        r = a * b;
        r = a / b;
        r = a ** b;
        ir = ia % ib;
        ir = (a > b) ? 1 : 0;
        ir = (a < b) ? 1 : 0;
        ir = (a >= b) ? 1 : 0;
        ir = (a <= b) ? 1 : 0;
        ir = (a == b) ? 1 : 0;
        ir = (a != b) ? 1 : 0;
        ir = (ia && ib) ? 1 : 0;
        ir = (ia || ib) ? 1 : 0;
        ir = !ia;
        ir = ~ia;
        ir = ia & ib;
        ir = ia | ib;
        ir = ia ^ ib;
        ir = ia ~^ ib;
        ir = ia ^~ ib;
        ir = ia << 2;
        ir = ia >> 1;
        I(p, n) <+ r;
    end
endmodule
