// Conformance: 5.3.2 — Named blocks with local variables
// EXPECT: compile_ok
`include "disciplines.vams"
module conf_ab_named(p, n);
    inout p, n;
    electrical p, n;
    real result;
    analog begin
        begin : calc
            real local_var;
            local_var = V(p, n) * 2.0;
            result = local_var + 1.0;
        end
        I(p, n) <+ result;
    end
endmodule
