// Conformance: 5.8.3 — Case statement
// EXPECT: compile_ok
`include "disciplines.vams"
module conf_ab_case(p, n);
    inout p, n;
    electrical p, n;
    parameter integer mode = 0;
    analog begin
        case (mode)
            0: I(p, n) <+ V(p, n) / 1.0k;
            1: I(p, n) <+ V(p, n) / 2.0k;
            2: I(p, n) <+ V(p, n) / 3.0k;
            default: I(p, n) <+ 0;
        endcase
    end
endmodule
