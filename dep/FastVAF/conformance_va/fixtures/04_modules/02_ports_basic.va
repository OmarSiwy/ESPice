// Conformance: 6.5 — Basic port list
// EXPECT: compile_ok
`include "disciplines.vams"
module conf_mod_ports(a, b, c);
    inout a, b, c;
    electrical a, b, c;
    analog
        I(a, b) <+ V(a, b) / 1.0k;
endmodule
