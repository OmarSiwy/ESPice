// Conformance: 6.2 — Empty module
// EXPECT: compile_ok
module conf_mod_empty;
endmodule
