// Simple diode model with temperature dependence
module diode(a, c);
    inout a, c;
    electrical a, c;

    parameter real IS = 1.0e-14 from (0:inf);
    parameter real N  = 1.0 from (0.1:10);
    parameter real CJ0 = 0.0 from [0:inf);
    parameter real VJ = 0.7 from (0:inf);
    parameter real RS = 0.0 from [0:inf);

    real Vd, Id, Qd, Vt;

    analog begin
        Vt = $vt;
        Vd = V(a, c);

        // DC current
        Id = IS * (limexp(Vd / (N * Vt)) - 1.0);

        // Junction charge
        if (Vd < 0.5 * VJ)
            Qd = CJ0 * VJ * (1.0 - sqrt(1.0 - Vd / VJ));
        else
            Qd = CJ0 * Vd;

        // Contributions
        I(a, c) <+ Id;
        I(a, c) <+ ddt(Qd);

        // Series resistance
        if (RS > 0.0)
            I(a, c) <+ V(a, c) * RS;
    end
endmodule
