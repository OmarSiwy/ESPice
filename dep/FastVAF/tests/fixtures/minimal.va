module minimal(a, b);
    inout a, b;
    electrical a, b;
    parameter real R = 100.0;
    analog begin
        I(a, b) <+ V(a, b) / R;
    end
endmodule
