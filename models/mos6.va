// MOS level 6 -- Sakurai-Newton empirical MOSFET (ngspice netlist letter M,
// LEVEL=6).
//
// Channel block: docs/mos-legacy.md S1.3 / S3 `mos6_channel` (source-verified
// against mos6load.c): power-law Vdsat/Idsat, the (2-u)u parabolic linear
// blend, lambda = lamda0 - lamda1*vb.
// Chassis: docs/mos1-shichman-hodges.md S1.2-1.8 -- d'/s' series nodes, bulk
// junction diodes + depletion charge, Meyer gate caps, mode swap, SPICE
// temperature maps.
// Voltage limiting (S1.7 fetlim/limvds/pnjlim) is spelled with $limit as in
// diode.va and mos1.va: $limit stays the identity inside eval, and VerA's
// contract `limit`/`seed` hooks hand the host the clamps to run between the
// linear solve and the next eval (codegen.zig S4.5.15).
module mos6(d, g, s, b);
    inout d, g, s, b;
    electrical d, g, s, b;
    electrical di, si;              // internal drain / source behind rd, rs
    branch (d, di) brd;
    branch (s, si) brs;

    // ---- channel (Sakurai-Newton), ngspice MOS6 names/defaults -------------
    parameter integer mtype = 1 from [-1:1] exclude 0;  // +1 NMOS, -1 PMOS
    parameter real vto     = 0.0;                       // V
    // KV = 0 is legal in ngspice (vdsat collapses to 0 => always the saturation
    // expression); mos6set.c range-checks nothing but PHI > 0.
    parameter real kv      = 2.0     from [0:inf);      // V^(1-nv)
    parameter real nv      = 0.5;
    parameter real kc      = 5e-5    from [0:inf);      // A/V^nc
    parameter real nc      = 1.0;
    parameter real u0      = 600.0;                     // cm^2/Vs (KC default)
    parameter real nsub    = 0.0     from [0:inf);      // cm^-3 substrate doping
    parameter real nss     = 0.0     from [0:inf);      // cm^-2 surface states
    parameter real tpg     = 1.0     from [-1:1];       // gate: +1 opp, -1 same, 0 Al
    parameter real gamma   = 0.0     from [0:inf);      // sqrt(V)
    parameter real gamma1  = 0.0;                       // 1/V linear body term
    parameter real sigma   = 0.0;                       // DIBL
    parameter real phi     = 0.6     from (0:inf);      // V
    parameter real lambda  = 0.0;                       // 1/V
    parameter real lambda0 = 0.0;                       // 1/V (defaults to lambda)
    parameter real lambda1 = 0.0;                       // 1/V^2

    // ---- series resistance ------------------------------------------------
    parameter real rd  = 0.0 from [0:inf);   // ohm (0 => d' collapses onto d)
    parameter real rs  = 0.0 from [0:inf);   // ohm
    parameter real rsh = 0.0 from [0:inf);   // ohm/square
    parameter real nrd = 1.0 from [0:inf);   // squares (0/absent => 1 square)
    parameter real nrs = 1.0 from [0:inf);

    // ---- bulk junctions ---------------------------------------------------
    parameter real is   = 1e-14 from [0:inf);  // A
    parameter real js   = 0.0   from [0:inf);  // A/m^2
    parameter real pb   = 0.8   from (0:inf);  // V
    parameter real cbd  = 0.0   from [0:inf);  // F
    parameter real cbs  = 0.0   from [0:inf);  // F
    parameter real cj   = 0.0   from [0:inf);  // F/m^2
    parameter real cjsw = 0.0   from [0:inf);  // F/m
    // MJ/MJSW = 0 is legal (constant sarg); only 1.0 must go, jqdep / f4 divide
    // by (1 - m).
    parameter real mj   = 0.5   from [0:1);
    parameter real mjsw = 0.5   from [0:1);
    parameter real fc   = 0.5   from (0:1);
    parameter real gmin = 1e-12 from [0:inf);

    // ---- oxide / overlap --------------------------------------------------
    parameter real tox  = 0.0 from [0:inf);  // m
    parameter real cgso = 0.0 from [0:inf);  // F/m
    parameter real cgdo = 0.0 from [0:inf);  // F/m
    parameter real cgbo = 0.0 from [0:inf);  // F/m
    parameter real ld   = 0.0 from [0:inf);  // m lateral diffusion
    parameter real tnom = $simparam("tnom") + 273.15 from (0:inf);

    // ---- flicker noise ----------------------------------------------------
    parameter real kf = 0.0 from [0:inf);
    parameter real af = 1.0 from (0:inf);

    // ---- geometry (instance) ----------------------------------------------
    // SPICE DEFW/DEFL (CKTdefaultMosW/L), not 1 um.
    parameter real w  = 1e-4 from (0:inf);
    parameter real l  = 1e-4 from (0:inf);
    parameter real m  = 1.0  from (0:inf);
    parameter real ad = 0.0  from [0:inf);   // m^2 drain area
    parameter real as = 0.0  from [0:inf);   // m^2 source area
    parameter real pd = 0.0  from [0:inf);   // m drain perimeter
    parameter real ps = 0.0  from [0:inf);   // m source perimeter

    // bias-independent prep
    real ty, leff, weff, coxp, coxn, cox, betac, lam0, grd, grs, sqd, sqs;
    real temp, vt, vtnom, eg, egnom, fact1, fact2, arg1, argt;
    real kcx, phix, gammax, vtox, fermis, fermig, wkfng, wkfngs, vfb;
    real pbfact1, pbfactt, phio, phit, sqphi, pbo, pbt, vbit, ist;
    real gmaold, gmanew, capf, capfsw, isats, isatd, czbs, czbd, czbssw, czbdsw;
    real vcrits, vcritd;
    // bias-dependent
    real vgs, vds, vbs, vbd, vgd, vgx, vb, vdse, mode, sarg, von, vgon;
    real ux, lvgon;
    real vdsat, vdsatm, idsat, lam, u, fu, clm, idch, gmch, ibs, ibd;
    real cgsm, cgdm, cgbm, cbase, vdd, vdd1, cgsb, cgdb;

    // Junction depletion charge for one plate: the reverse-bias closed form
    // below fc*pj, and above it the C0-continuous linearization C = f2 + f3*v
    // (docs/mos1-shichman-hodges.md S1.3) -- here derived from the same closed
    // form, so C and Q match value and slope at v = fc*pj.
    analog function real jqdep;
        input v, cz, pj, mg, fcc;
        real v, cz, pj, mg, fcc;
        real k1, v0, c0, cp, q0, dv;
        begin
            k1 = cz * pj / (1.0 - mg);
            v0 = fcc * pj;
            // mos6load.c:581,640's own guard (`if (Cbs != 0 || Cbssw != 0)`).
            // Every term below carries `cz`, so with no junction capacitance
            // the charge is exactly zero — reached, without this, through two
            // `pow` per junction per Newton iteration. Same guard mos2/mos3
            // already carry.
            if (cz == 0.0) jqdep = 0.0;
            else if (v < v0) begin
                jqdep = k1 * (1.0 - pow(1.0 - v / pj, 1.0 - mg));
            end else begin
                c0 = cz * pow(1.0 - fcc, -mg);
                cp = c0 * mg / (pj * (1.0 - fcc));
                q0 = k1 * (1.0 - pow(1.0 - fcc, 1.0 - mg));
                dv = v - v0;
                jqdep = q0 + c0 * dv + 0.5 * cp * dv * dv;
            end
        end
    endfunction

    analog begin
        // ==================================================================
        // Bias-independent prep (no V() below this banner)
        // ==================================================================
        ty   = mtype;
        leff = max(l - 2.0 * ld, 1e-9);
        weff = w;

        // Oxide capacitance. tox not given => no intrinsic Meyer caps, as in
        // ngspice (oxideCapFactor stays 0).
        if (tox > 0.0) coxp = 3.9 * 8.854187817e-12 / tox;
        else coxp = 0.0;
        cox = coxp * weff * leff * m;
        // Flicker noise uses mos1noi.c's nominal TOX = 1e-7 when Cox' is 0.
        if (coxp > 0.0) coxn = coxp;
        else coxn = 3.9 * 8.854187817e-12 / 1e-7;

        // ---- SPICE temperature maps (mos1temp.c; identity at temp = tnom) --
        temp    = $temperature;
        vt      = 1.380649e-23 * temp / 1.602176634e-19;
        vtnom   = 1.380649e-23 * tnom / 1.602176634e-19;
        eg      = 1.16 - 7.02e-4 * temp * temp / (temp + 1108.0);
        egnom   = 1.16 - 7.02e-4 * tnom * tnom / (tnom + 1108.0);
        fact1   = tnom / 300.15;
        fact2   = temp / 300.15;
        // arg is ngspice's literal 1/Joule form; the q factor below converts it,
        // so it must NOT already be divided by q (that would cancel the term and
        // leave pbfact = -3*vt*ln(T/300.15)).
        arg1    = -egnom / (2.0 * 1.380649e-23 * tnom)
                  + 1.1150877 / (2.0 * 1.380649e-23 * 300.15);
        argt    = -eg / (2.0 * 1.380649e-23 * temp)
                  + 1.1150877 / (2.0 * 1.380649e-23 * 300.15);
        pbfact1 = -2.0 * vtnom * (1.5 * ln(fact1) + 1.602176634e-19 * arg1);
        pbfactt = -2.0 * vt * (1.5 * ln(fact2) + 1.602176634e-19 * argt);

        // ---- model-card preprocessing (mos6temp.c, MOS1's rules) -----------
        // "Given" is $param_given, not a value test: every default here (KC,
        // PHI, GAMMA, VTO) is also a legal user value.
        phix   = phi;
        gammax = gamma;
        vtox   = vto;
        if ($param_given(nsub) && nsub * 1e6 > 1.45e16) begin
            if (!$param_given(phi)) phix = max(0.1, 2.0 * vtnom * ln(nsub * 1e6 / 1.45e16));
            if (coxp > 0.0) begin   // both remaining overrides divide by Cox'
                if (!$param_given(gamma))
                    gammax = sqrt(2.0 * 11.7 * 8.854187817e-12
                                  * 1.602176634e-19 * nsub * 1e6) / coxp;
                if (!$param_given(vto)) begin
                    fermis = ty * 0.5 * phix;
                    if (tpg != 0.0) begin
                        fermig = tpg * ty * 0.5 * egnom;
                        wkfng  = 3.25 + 0.5 * egnom - fermig;
                    end else wkfng = 3.2;
                    wkfngs = wkfng - (3.25 + 0.5 * egnom + fermis);
                    vfb    = wkfngs - nss * 1e4 * 1.602176634e-19 / coxp;
                    vtox   = vfb + ty * (gammax * sqrt(phix) + phix);
                end
            end
        end
        // KC from TOX/U0 -- note the extra 0.5 relative to MOS1's KP rule.
        if ($param_given(kc)) kcx = kc;
        else kcx = 0.5 * u0 * coxp * 1e-4;

        // Surface potential and built-in voltage at T.
        phio  = (phix - pbfact1) / fact1;
        phit  = max(fact2 * phio + pbfactt, 1e-6);
        sqphi = sqrt(phit);
        vbit  = vtox - ty * gammax * sqrt(phix)
                + 0.5 * (egnom - eg) + ty * 0.5 * (phit - phix);

        // Junction potential at T + the two-stage depletion-cap factor.
        pbo    = (pb - pbfact1) / fact1;
        pbt    = max(fact2 * pbo + pbfactt, 1e-6);
        gmaold = (pb - pbo) / pbo;
        gmanew = (pbt - pbo) / pbo;
        capf   = (1.0 + mj * (4e-4 * (temp - 300.15) - gmanew))
                 / (1.0 + mj * (4e-4 * (tnom - 300.15) - gmaold));
        capfsw = (1.0 + mjsw * (4e-4 * (temp - 300.15) - gmanew))
                 / (1.0 + mjsw * (4e-4 * (tnom - 300.15) - gmaold));

        // Saturation currents at T (mos1 S1.3).
        ist = exp(-eg / vt + egnom / vtnom);
        // JS wins only when BOTH areas are given: ngspice decides once for the
        // pair (mos6load.c:127-138), never mixing IS on one junction with JS*A
        // on the other.
        if (js > 0.0 && ad > 0.0 && as > 0.0) begin
            isats = js * as * m * ist;
            isatd = js * ad * m * ist;
        end else begin
            isats = is * m * ist;
            isatd = is * m * ist;
        end

        // Junction depletion-cap magnitudes (bottom + sidewall).
        if (cbs > 0.0) czbs = cbs * m * capf;
        else czbs = cj * as * m * capf;
        if (cbd > 0.0) czbd = cbd * m * capf;
        else czbd = cj * ad * m * capf;
        // Spelled as a phi, like czbs/czbd two lines up, and for a reason
        // that is not cosmetic: jqdep's `cz == 0.0` guard is a BRANCH
        // CONDITION, and VerA re-expands a straight-line parameter expression
        // inline at a condition instead of reading the precomputed slot — so
        // the whole capfsw temperature ratio was re-derived twice per
        // instance-eval just to be compared against zero (34 Ir/eval measured
        // on devices/mos6_inverter). A phi is materialised, so both arms
        // hoist. CJSW is `from [0:inf)`, so the else arm is the value the
        // product already had.
        if (cjsw > 0.0) czbssw = cjsw * ps * m * capfsw; else czbssw = 0.0;
        if (cjsw > 0.0) czbdsw = cjsw * pd * m * capfsw; else czbdsw = 0.0;

        // Channel prefactor: betac = KC * W * m / Leff, KC temperature-scaled
        // like MOS1's KP (mos1 S1.3: KP(T) = KP / (T/Tnom)^1.5).
        betac = kcx * weff * m / (leff * pow(temp / tnom, 1.5));

        // lamda0 defaults to LAMBDA when not given (mos6set.c).
        if (lambda0 != 0.0) lam0 = lambda0;
        else lam0 = lambda;

        // Series conductances. R = 0 and no sheet resistance => the prime node
        // collapses onto the terminal (mos1 S1.8), a switch branch here.
        // Squares default to 1 whenever RSH is given (mos6temp.c:294-327), so
        // `.model ... RSH=20` alone still produces the series resistance.
        if (nrd > 0.0) sqd = nrd; else sqd = 1.0;
        if (nrs > 0.0) sqs = nrs; else sqs = 1.0;
        if (rd > 0.0) grd = m / rd;
        else if (rsh > 0.0) grd = m / (rsh * sqd);
        else grd = 0.0;
        if (rs > 0.0) grs = m / rs;
        else if (rsh > 0.0) grs = m / (rsh * sqs);
        else grs = 0.0;

        // ==================================================================
        // Bias — S1.7 limiting, mos1.va's MODE ladder: "fetlimds" on both
        // gate legs + "limvds" emits ngspice's old-vds swap (mos6load.c:
        // 353-366); pnjlim stays on both bulk junctions (see mos1.va).
        // Trailing `ty` = VerA frame sign (PMOS limits ty·v).
        // ==================================================================
        vcrits = vt * ln(vt / (1.4142135623730951 * isats));
        vcritd = vt * ln(vt / (1.4142135623730951 * isatd));
        vgs = ty * $limit(V(g, si), "fetlimds", ty * vtox, ty);
        vgd = ty * $limit(V(g, di), "fetlimds", ty * vtox, ty);
        vds = ty * $limit(V(di, si), "limvds", ty);
        vgd = vgs - vds;
        vbs = ty * $limit(V(b, si), "pnjlim", vt, vcrits, ty);
        vbd = ty * $limit(V(b, di), "pnjlim", vt, vcritd, ty);

        // Mode swap: reversed drain/source roles for vds < 0 (mos1 S1.5).
        if (vds >= 0.0) begin
            mode = 1.0;
            vgx  = vgs;
            vb   = vbs;
            vdse = vds;
        end else begin
            mode = -1.0;
            vgx  = vgs - vds;
            vb   = vbd;
            vdse = -vds;
        end

        // Body term with the MOS1 Taylor guard (keeps sarg >= 0 for vb > 0).
        if (vb <= 0.0) sarg = sqrt(max(phit - vb, 0.0));
        else sarg = max(0.0, sqphi - vb / (2.0 * sqphi));

        // ---- MOS6 threshold and overdrive (mos-legacy S1.3) ---------------
        von  = ty * vbit + gammax * sarg - gamma1 * vb - sigma * vdse;
        vgon = vgx - von;

        // Power-law Vdsat is also needed by the Meyer block below cutoff —
        // but THERE the base is the 1e-30 floor, so vdsat is a
        // parameter-only constant and vdsatm collapses onto the DEVqmeyer
        // floor. Writing the two arms out keeps that `pow` off the hot path
        // (the cutoff arm hoists to precompute) instead of paying it on the
        // 49% of instance-evals that are in cutoff — 105 Ir/eval measured on
        // devices/mos6_inverter, 7% of the kernel. Bit-identical:
        // max(vgon,0) IS vgon on the taken arm, and the derivative the
        // untaken one used to carry is discarded by max(vdsat, 0.025) for
        // every parameter set where kv*1e-30^nv < 0.025.
        // ngspice does not compute it in cutoff either (mos6load.c:493).
        // One ln shared by BOTH power laws, exactly as mos6load.c:502-505
        // spells it (`sarg1 = log(vgon); vdsat = KV*exp(sarg1*NV);
        // idsat = betac*exp(sarg1*NC)`). Two pow calls become one ln + two
        // exp — gompute's pow IS an ln plus an exp, so this halves the libm
        // work of the channel block and puts our transcendental profile on
        // ngspice's. DELIBERATE NUMERICS CHANGE: it trades pow's ~0.5 ulp for
        // exp(ln)'s ~2 ulp. Measured against the unpatched kernel over all
        // 25,360 real biases of devices/mos6_inverter plus an 8,820-point
        // torture grid: worst relative deviation 1.3e-13, ten orders below
        // RELTOL. It moves TOWARDS the reference — this is ngspice's own
        // arithmetic. Worth -75 Ir/eval measured in isolation.
        if (vgon > 0.0) begin
            lvgon = ln(vgon);                  // vgon > 0 here, no floor needed
            vdsat = max(kv * exp(lvgon * nv), 1e-30);
        end else begin
            lvgon = 0.0;
            vdsat = max(kv * pow(1e-30, nv), 1e-30);
        end
        vdsatm = max(vdsat, 0.025);          // DEVqmeyer MAGIC_VDS floor

        // ---- channel current ----------------------------------------------
        // u = min(vds/vdsat, 1) folds saturation into the linear expression:
        // f(1) = 1, so id = idsat*(1+lam*vds) there. Only C0 in gds at the
        // seam -- that is level 6's documented wart, not a smoothing bug.
        idch = 0.0;
        gmch = 0.0;
        if (vgon > 0.0) begin
            idsat = betac * exp(lvgon * nc);   // shares the ln above
            lam   = lam0 - lambda1 * vb;
            clm   = 1.0 + lam * vdse;
            u     = min(vdse / vdsat, 1.0);
            fu    = (2.0 - u) * u;
            idch  = idsat * clm * fu;
            // d(idch)/d(vgon), exact for the expression above: the nc*fu term
            // is the doc's gm = id*nc/vgon, the second is the blend's du term.
            gmch  = idsat * clm * (nc * fu - 2.0 * nv * u * (1.0 - u)) / vgon;
        end

        // ---- bulk junction diodes (mos1 S1.4). Exponent tangent-continued
        // above 80·vt: pnjlim keeps Newton iterates below it, but LTE probes
        // and sweep warm starts evaluate at unlimited x, and a flat clamp
        // there zeroes the restoring slope (see bjt.va pnj).
        if (vbs > -3.0 * vt) begin
            ux  = min(vbs / vt, 80.0);
            ibs = isats * (exp(ux) * (1.0 + (vbs / vt - ux)) - 1.0) + gmin * vbs;
        end else ibs = gmin * vbs - isats;
        if (vbd > -3.0 * vt) begin
            ux  = min(vbd / vt, 80.0);
            ibd = isatd * (exp(ux) * (1.0 + (vbd / vt - ux)) - 1.0) + gmin * vbd;
        end else ibd = gmin * vbd - isatd;

        // ==================================================================
        // Meyer intrinsic gate capacitances (mos1 S1.6, DEVqmeyer).
        // Values are the steady-state totals (2x the half-caps ngspice
        // stores); the stamps average 0.5*(now + $prev(now)) — identical to
        // ngspice's half_now + half_prev MODETRAN sum, with the steady-state
        // total at OP/AC via $prev's commit at OP exit.
        // ==================================================================
        cgsm = 0.0;
        cgdm = 0.0;
        cgbm = 0.0;
        if (vgon <= -phit) begin
            cgbm = cox;                                   // accumulation
        end else if (vgon <= -0.5 * phit) begin
            cgbm = -vgon * cox / phit;                    // depletion
        end else if (vgon <= 0.0) begin
            cgbm  = -vgon * cox / phit;                   // weak inversion
            cbase = vgon * 2.0 * cox / (1.5 * phit) + 2.0 * cox / 3.0;
            if (vdse >= vdsatm) begin
                cgsm = cbase;
            end else begin
                vdd  = max(2.0 * vdsatm - vdse, 1e-30);
                vdd1 = vdsatm - vdse;
                cgsm = cbase * (1.0 - vdd1 * vdd1 / (vdd * vdd));
                cgdm = cbase * (1.0 - vdsatm * vdsatm / (vdd * vdd));
            end
        end else if (vdse >= vdsatm) begin
            cgsm = 2.0 * cox / 3.0;                       // strong inv, sat
        end else begin
            vdd  = max(2.0 * vdsatm - vdse, 1e-30);       // strong inv, linear
            vdd1 = vdsatm - vdse;
            cgsm = 2.0 * cox / 3.0 * (1.0 - vdd1 * vdd1 / (vdd * vdd));
            cgdm = 2.0 * cox / 3.0 * (1.0 - vdsatm * vdsatm / (vdd * vdd));
        end
        // Reversed mode: the channel-side Meyer caps swap terminals.
        if (mode > 0.0) begin
            cgsb = cgsm;
            cgdb = cgdm;
        end else begin
            cgsb = cgdm;
            cgdb = cgsm;
        end

        // ==================================================================
        // Contributions
        // ==================================================================
        // Series resistance, or node collapse when it is zero.
        if (grd > 0.0) begin
            I(brd) <+ grd * V(brd) + white_noise(4.0 * 1.380649e-23 * temp * grd, "rd");
        end else begin
            V(brd) <+ 0.0;
        end
        if (grs > 0.0) begin
            I(brs) <+ grs * V(brs) + white_noise(4.0 * 1.380649e-23 * temp * grs, "rs");
        end else begin
            V(brs) <+ 0.0;
        end

        // Channel (mode-signed, type-mapped back to the real terminals).
        I(di, si) <+ ty * mode * idch;

        // Bulk junctions: DC current + depletion charge, bottom and sidewall.
        I(b, si) <+ ty * ibs
                  + ty * ddt(jqdep(vbs, czbs, pbt, mj, fc)
                             + jqdep(vbs, czbssw, pbt, mjsw, fc));
        I(b, di) <+ ty * ibd
                  + ty * ddt(jqdep(vbd, czbd, pbt, mj, fc)
                             + jqdep(vbd, czbdsw, pbt, mjsw, fc));

        // Gate: constant overlap + Meyer intrinsic. Meyer caps are
        // capacitance-based, not charge-conserving (mos1 S1.6: the reference
        // advances q = q_prev + cap*(v - v_prev)), so the Jacobian entry is
        // exactly cap. ddt(cap*v) would instead add a spurious v*dcap/dv --
        // O(100%) of cap in the depletion/weak-inversion bands and across the
        // whole vdsat split. Both plates are evaluated in the type-corrected
        // frame, where the two ty factors cancel.
        I(g, si) <+ (cgso * weff * m + 0.5 * (cgsb + $prev(cgsb))) * ddt(V(g, si));
        I(g, di) <+ (cgdo * weff * m + 0.5 * (cgdb + $prev(cgdb))) * ddt(V(g, di));
        I(g, b)  <+ (cgbo * leff * m + 0.5 * (cgbm + $prev(cgbm))) * ddt(V(g, b));

        // Channel noise (docs/mos-legacy.md noise table; mos1noi.c template).
        I(di, si) <+ white_noise(4.0 * 1.380649e-23 * temp * 2.0 / 3.0 * abs(gmch), "channel");
        // mos1noi.c:319 substitutes a nominal TOX = 1e-7 when Cox' is zero
        // rather than dropping the flicker source.
        if (kf > 0.0) begin
            I(di, si) <+ flicker_noise(kf * pow(abs(idch), af)
                                       / (weff * m * leff * coxn * coxn), 1.0, "flicker");
        end
    end
endmodule
