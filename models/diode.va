// Junction diode: Shockley law with series resistance, recombination,
// high injection, breakdown, depletion charge and temperature map.
//
// Verilog-A implementation: Omar El-Sawy, University of Waterloo.
// Based on: ngspice D element (dio/dioload.c, diotemp.c, diosetup.c,
//   dionoise.c), from Berkeley SPICE3.
//   ngspice: Copyright Regents of the University of California and others,
//   modified BSD license.
//
// The junction sits on internal node `ai` behind RS; with RS = 0 the branch is
// a 0 V short and the host collapses the node (Builder.addDevice, `collapse`).
//
// Junction limiting is $limit pnjlim with ngspice's
// vcrit = vte*ln(vte/(sqrt(2)*is)). The exponent is additionally
// tangent-continued past 80*vte, not at vcrit: vcrit is a step-limiting
// threshold and converged operating points sit above it. The 80*vte guard only
// keeps unlimited evaluations (LTE probes, sweeps) finite and monotone.
//
// Temperature (diotemp.c) is bias-independent and an exact no-op at
// T == Tnom (pbfact(Tnom) == pbfact1, since 1.1150877 is egfet at 300.15 K).
//   * vte/vtr/vtebrk are k*T/q at the operating temperature.
//   * IS(T) uses the flat EG parameter (TLEV 0/1); pbfact, which moves VJ and
//     CJO, uses the silicon bandgap 1.16 - 7.02e-4*T^2/(T+1108). Same split as
//     vdmos.va and mos1.va.
//
// ponytail: no sidewall (JSW/NS/CJP/PHP/MJSW/FCS/CTP/TPHP), no tunnel
// (JTUN/NTUN/XTITUN/KEG), no TTT1/TTT2 transit-time tempco. Add when a deck
// needs one.
module diode(a, c);
    inout a, c;
    electrical a, c, ai;
    branch (a, ai) rsb;

    parameter real is   = 1e-14  from (0:inf);  // A    saturation current
    parameter real n    = 1.0    from (0:inf);  //      emission coefficient
    parameter real rs   = 0.0    from [0:inf);  // ohm  series resistance
    parameter real ikf  = 0.0    from [0:inf);  // A    high-injection knee (0 = off)
    parameter real isr  = 0.0    from [0:inf);  // A    recombination sat current (0 = off)
    parameter real nr   = 2.0    from (0:inf);  //      recombination emission coefficient
    parameter real bv   = 0.0    from [0:inf);  // V    reverse breakdown knee (0 = off)
    parameter real ibv  = 1e-3   from (0:inf);  // A    current magnitude at bv
    parameter real cjo  = 0.0    from [0:inf);  // F    zero-bias junction capacitance
    parameter real vj   = 1.0    from (0:inf);  // V    junction potential
    parameter real m    = 0.5    from (0:inf);  //      grading coefficient (card key `m`)
    parameter real fc   = 0.5    from (0:1);    //      forward-bias depletion coefficient
    parameter real gmin = 1e-12  from [0:inf);  // S    junction shunt
    parameter real tt   = 0.0    from [0:inf);  // s    transit time (diffusion charge)

    // ---- temperature (diotemp.c / diosetup.c defaults) --------------------
    // tnom is in degC, like the ngspice TNOM/TREF card (diompar.c).
    parameter real tnom = $simparam("tnom");     // degC .model TNOM / TREF
    parameter integer tlev  = 0 from [0:2];      // IS / EG equation selector
    parameter integer tlevc = 0 from [0:1];      // VJ / CJO equation selector
    parameter real eg   = 1.11;                  // eV   activation energy (1.16 when TLEV=2)
    parameter real gap1 = 7.02e-4;               // eV/K first bandgap correction (TLEV=2)
    parameter real gap2 = 1108.0 from (0:inf);   // K    second bandgap correction (TLEV=2)
    parameter real xti  = 3.0    from [0:inf);   //      IS temperature exponent
    parameter real nbv  = 1.0    from (0:inf);   //      breakdown emission coeff (default N)
    parameter real tcv  = 0.0;                   //      BV temperature coefficient
    parameter real tm1  = 0.0;                   // 1/K   M linear temp coeff
    parameter real tm2  = 0.0;                   // 1/K^2 M quadratic temp coeff
    parameter real cta  = 0.0;                   // 1/K   CJO linear temp coeff (TLEVC=1)
    parameter real tpb  = 0.0;                   // V/K   VJ linear temp coeff (TLEVC=1)
    parameter real trs  = 0.0;                   // 1/K   RS linear temp coeff
    parameter real trs2 = 0.0;                   // 1/K^2 RS quadratic temp coeff

    real vt, vte, vd, vcrit, u, ulim, id, ihi, w, wlim, qj, f1, f2, f3, vfc;
    real vterec, ur, urlim, genfac, irec;
    // bias-independent temperature prep (diotemp.c)
    real tk, tnomk, ratio, dtk, vtnom, egp, nbvx, vtebrk;
    real egfet, egfet1, fact1, fact2, arg1, argt, pbfact, pbfact1;
    real pbo, gmaold, gmanew, mt, vj_t, cjo_t, is_t, isr_t, bv_t, rs_t, xbv;

    analog begin
        // ==== diotemp.c: bias-independent temperature map ===================
        tk    = $temperature;              // kelvin (LRM §9.10)
        tnomk = tnom + 273.15;
        ratio = tk / tnomk;                // diotemp.c Temp/DIOnomTemp
        dtk   = tk - tnomk;                // diotemp.c:48 `dt`
        vt    = 1.38064852e-23 / 1.6021766208e-19 * tk;
        vtnom = 1.38064852e-23 / 1.6021766208e-19 * tnomk;
        vte   = n * vt;                    // diotemp.c:39, OPERATING temp

        // diosetup.c: EG's default depends on TLEV, so it needs the
        // given-flag; XTI/VJ/CJO/CTA/TPB/TCV/TM1/TM2 are plain defaults.
        if ($param_given(eg)) egp = eg;
        else if (tlev == 2)   egp = 1.16;
        else                  egp = 1.11;
        // diosetup.c: NBV defaults to N.
        if ($param_given(nbv)) nbvx = nbv; else nbvx = n;
        vtebrk = nbvx * vt;

        // diotemp.c: TLEV 0/1 take the hardcoded silicon curve; TLEV=2
        // takes EG/GAP1/GAP2. This egfet feeds pbfact (VJ/CJO) always, and
        // feeds IS(T) only on the TLEV=2 arm.
        if (tlev == 2) begin
            egfet  = egp - (gap1 * tk * tk)       / (tk + gap2);
            egfet1 = egp - (gap1 * tnomk * tnomk) / (tnomk + gap2);
        end else begin
            egfet  = 1.16 - (7.02e-4 * tk * tk)       / (tk + 1108.0);
            egfet1 = 1.16 - (7.02e-4 * tnomk * tnomk) / (tnomk + 1108.0);
        end

        // diotemp.c: M(T), TM1/TM2.
        mt = m * (1.0 + tm1 * dtk + tm2 * dtk * dtk);

        // diotemp.c: REFTEMP is 300.15 K, and 1.1150877 is egfet at
        // REFTEMP, which is why pbfact(Tnom) == pbfact1 exactly.
        fact1 = tnomk / 300.15;
        fact2 = tk    / 300.15;
        arg1  = -egfet1 / (2.0 * 1.38064852e-23 * tnomk)
              +  1.1150877 / (2.0 * 1.38064852e-23 * 300.15);
        argt  = -egfet  / (2.0 * 1.38064852e-23 * tk)
              +  1.1150877 / (2.0 * 1.38064852e-23 * 300.15);
        pbfact1 = -2.0 * vtnom * (1.5 * ln(fact1) + 1.6021766208e-19 * arg1);
        pbfact  = -2.0 * vt    * (1.5 * ln(fact2) + 1.6021766208e-19 * argt);

        // diotemp.c: VJ(T), CJO(T). The C's divide-by-Tnom-bracket,
        // multiply-by-T-bracket written as one ratio (1 at T == Tnom).
        if (tlevc == 1) begin
            vj_t  = vj  - tpb * (tk - 300.15);
            cjo_t = cjo * (1.0 + cta * (tk - 300.15));
        end else begin
            pbo    = (vj - pbfact1) / fact1;
            gmaold = (vj - pbo) / pbo;
            vj_t   = pbfact + fact2 * pbo;
            gmanew = (vj_t - pbo) / pbo;
            cjo_t  = cjo * (1.0 + mt * (400e-6 * (tk    - 300.15) - gmanew))
                         / (1.0 + mt * (400e-6 * (tnomk - 300.15) - gmaold));
        end

        // diotemp.c IS(T), TLEV 0/1 and TLEV 2. vte, not vtnom, in the EG
        // term, as in ngspice.
        if (tlev == 2)
            is_t = is * exp(egfet1 / (n * vtnom) - egfet / vte + (xti / n) * ln(ratio));
        else
            is_t = is * exp((ratio - 1.0) * egp / vte + (xti / n) * ln(ratio));

        // diotemp.c: ISR(T) rides NR and reuses XTI.
        vterec = nr * vt;
        if (tlev == 2)
            isr_t = isr * exp(egfet1 / (nr * vtnom) - egfet / vterec + (xti / nr) * ln(ratio));
        else
            isr_t = isr * exp((ratio - 1.0) * egp / vterec + (xti / nr) * ln(ratio));

        // diotemp.c: BV(T); TLEV 0 is subtractive, TLEV 1/2 scaling.
        if (tlev == 0) bv_t = bv - tcv * dtk;
        else           bv_t = bv * (1.0 - tcv * dtk);

        // diotemp.c: the breakdown knee xbv, placed so the breakdown branch
        // -is(T)*exp(-(xbv+vd)/vtebrk) carries IBV at vd = -BV(T). An IBV
        // too small to resolve against IS keeps xbv = BV(T).
        // ponytail: one refinement of ngspice's fixed-point loop, which
        // meets its reltol*IBV test on that first pass for any real card.
        xbv = bv_t;
        if (bv > 0.0 && ibv >= is_t * bv_t / vt) begin
            xbv = bv_t - vtebrk * ln(1.0 + ibv / is_t);
            xbv = bv_t - vtebrk * ln(ibv / is_t + 1.0 - xbv / vt);
        end

        // diotemp.c: RS(T). Floored like vdmos.va's rtemp(): the quadratic
        // can be driven <= 0 and the stamp below divides by it.
        rs_t = rs * (1.0 + trs * dtk + trs2 * dtk * dtk);
        if (rs_t < 1.0e-9) rs_t = 1.0e-9;

        // ==== bias-dependent ================================================
        // pnjlim first, where dioload.c runs it. The tangent continuation
        // below guards evaluations at unlimited voltage.
        vcrit = vte * ln(vte / (1.4142135623730951 * is_t));   // diotemp.c
        vd  = $limit(V(ai, c), "pnjlim", vte, vcrit);

        // Forward/reverse ideal current, tangent-continued past 80*vte.
        // Clamped in ratio space so the finiteness prover sees exp's argument
        // bounded by the literal 80.
        u     = vd / vte;
        ulim  = min(u, 80.0);
        id    = is_t * ((exp(ulim) * (1.0 + (u - ulim))) - 1.0);

        // ISR/NR recombination current (dioload.c), forward region only
        // (vd >= -3*vte): isr(T)*(e^{vd/(nr*vt)}-1)
        // times the depletion generation factor ((1-vd/vj(T))^2+0.005)^(M(T)/2).
        // NR multiplies the raw vt, not vte. Same tangent continuation past 80.
        irec = 0.0;
        if (isr > 0.0 && vd >= -3.0 * vte) begin
            ur     = vd / vterec;
            urlim  = min(ur, 80.0);
            genfac = pow((1.0 - vd / vj_t) * (1.0 - vd / vj_t) + 0.005, mt / 2.0);
            irec   = isr_t * ((exp(urlim) * (1.0 + (ur - urlim))) - 1.0) * genfac;
        end

        // High-injection roll-off, IKF (dioload.c): cd / (1 + sqrt(cd/ikf))
        // on the total forward current, recombination included. The
        // ihi > 0 guard keeps the reverse branch untouched and the sqrt
        // argument non-negative. IKF has no temperature coefficient.
        ihi = id + irec;
        if (ikf > 0.0 && ihi > 0.0)
            ihi = ihi / (1.0 + sqrt(ihi / ikf));

        // Reverse breakdown (dioload.c): past -xbv the junction current is
        // REPLACED by -is(T)*exp(-(xbv+vd)/vtebrk), vtebrk = NBV*vt; it
        // reads -is at the knee and -IBV at -BV(T). Armed off the raw bv, as
        // ngspice's DIObreakdownVoltageGiven, and only below -3*vte, where
        // ngspice's forward branch ends. ngspice runs a mirrored pnjlim here,
        // which $limit cannot spell; the tangent continuation past
        // 80*vtebrk keeps Newton finite instead. Ratio-space clamp, as above.
        if (bv > 0.0 && vd < -3.0 * vte && vd < -xbv) begin
            w    = -(xbv + vd) / vtebrk;
            wlim = min(w, 80.0);
            ihi  = -is_t * exp(wlim) * (1.0 + (w - wlim));
        end

        I(ai, c) <+ ihi + gmin * vd;

        // Noise (LRM §4.6.4, dionoise.c): shot noise of the junction current,
        // 2q|Id|, across (DIOposPrimeNode, DIOnegNode) = (ai, c); RS thermal
        // noise is in the series branch below. Flicker is gated on KF, which
        // ngspice defaults to 0 and this model does not carry.
        // ponytail: the host derives each generator's PSD from the Jacobian
        // as 4kT*g (collectNoise), exact for a resistor but 2x high in power
        // for a junction (4q*Id vs 2q*Id), because VerA tags every
        // white_noise `.thermal`. Fix via the contract's `noisePsd` hook; all
        // shot-noise models in the tree share this ceiling.
        I(ai, c) <+ white_noise(2.0 * 1.6021766208e-19 * abs(ihi), "id");

        // One junction charge, depletion plus diffusion, in one ddt site:
        // ngspice truncates it as the single state DIOcapCharge (diotrunc.c).
        qj = 0.0;
        // Depletion charge, CJO(T)/VJ(T)/M(T). Below fc*vj(T) it is the exact
        // integral of cjo(T)*(1-v/vj(T))^-M(T); above it the linearized
        // f1/f2/f3 continuation (diotemp.c) avoids the singularity at v = vj.
        if (cjo > 0.0) begin
            vfc = fc * vj_t;
            if (vd < vfc) begin
                qj = cjo_t * vj_t * (1.0 - pow(1.0 - vd / vj_t, 1.0 - mt)) / (1.0 - mt);
            end else begin
                f1 = vj_t * (1.0 - pow(1.0 - fc, 1.0 - mt)) / (1.0 - mt);
                f2 = pow(1.0 - fc, 1.0 + mt);
                f3 = 1.0 - fc * (1.0 + mt);
                qj = cjo_t * (f1 + (1.0 / f2) *
                     (f3 * (vd - vfc) + (mt / (2.0 * vj_t)) * (vd * vd - vfc * vfc)));
            end
        end

        // Diffusion charge TT*cd (dioload.c), cd the whole junction current
        // including the gmin shunt, so its small-signal cap is TT*gd.
        if (tt > 0.0) qj = qj + tt * (ihi + gmin * vd);
        I(ai, c) <+ ddt(qj);

        // Guard on the raw rs: node collapse is a topology decision and must
        // not depend on temperature. rs_t is floored above.
        // RS thermal noise 4kT/rs(T) (dionoise.c) across (DIOposPrimeNode,
        // DIOposNode). With rs == 0 the node is collapsed and the generator
        // contributes nothing, as in ngspice.
        if (rs > 0.0) begin
            I(rsb) <+ V(rsb) / rs_t;
            I(rsb) <+ white_noise(4.0 * 1.38064852e-23 * tk / rs_t, "rs");
        end else V(rsb) <+ 0.0;
    end
endmodule
