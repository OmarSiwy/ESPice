// Current-controlled current source (ngspice F). i(p,n) = m * gain * i_ctrl.
//
// Port order is the netlist order: F<name> p n <vnam> <gain>, with (cp,cn)
// standing in for `vnam`. ngspice takes the control current from a named
// V-source's branch unknown (cccsset.c CKTfndBranch); a VA module has no
// cross-instance handle, so (cp,cn) is an explicit sense branch here and the
// netlist layer wires it in place of that V-source. `vsense` carries the
// replaced source's DC value so `V1 a b DC 5` + `F1 p n V1 2` keeps its 5 V
// (doc §1.5: the control quantity is that source's *branch unknown* — the
// source keeps its own value; it is not a forced 0 V ammeter).
//
// `m` is ngspice's parallel multiplier (cccs.c CCCS_M, default 1), folded into
// the transfer exactly as cccspar.c does (`coeff = value; if (mGiven) coeff *=
// mValue`) and as the sibling vccs.va does.
//
// Constant stamp: no bias dependence, no charge, no limiting (doc §1.5).
//
// ponytail: one F/H consumer per `vnam` -- the sense branch is private to the
// instance, and two of them across the same node pair is a singular MNA row.
// Sharing one branch unknown between several consumers (doc §1.5, one shared
// I_br,ctrl) has to happen host-side, not in this module.
module cccs(p, n, cp, cn);
    inout p, n, cp, cn;
    electrical p, n, cp, cn;
    branch (cp, cn) ctrl;

    parameter real gain   = 1.0;              // current gain, A/A
    parameter real m      = 1.0 from (0:inf); // parallel multiplier
    parameter real vsense = 0.0;              // DC value of the replaced control V-source, V

    real k;
    analog begin
        // Bias-independent parameter prep, hoisted out of the I() chain.
        k = m * gain;

        V(ctrl) <+ vsense;
        I(p, n) <+ k * I(ctrl);
    end
endmodule
