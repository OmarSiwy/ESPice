// BSIM1 (Berkeley Short-Channel IGFET Model 1), ngspice level 4, letter M.
//
// Spec: modules/devices/docs/mos-legacy.md §1.5 (structure) + the BSIM1
// parameter/equation reference (docs/bsim1.md, recovered from git history) which
// mos-legacy names as the operative reference for this level.
//
// Topology: d-g-s-b external, d'/s' internal series-resistance nodes. Channel
// between d' and s', bulk diodes b-d'/b-s', charge-based caps (no Meyer).
//
// Everything above the "bias-dependent" marker is geometry/parameter prep and
// carries no V() probe, per the doc's setup/load split.
//
// Deliberate divergences from docs/bsim1.md (which was written off the old
// bsim1.zig port and inherits its bugs):
//   * PB/PBSW clamp is 0.1, not the doc table's 0.01 (b1temp.c).
//   * The junction currents/charges carry `type` and are evaluated on the true
//     node voltages, and the intrinsic drain charge is un-swapped for
//     V(di,si) < 0 -- the doc's KCL/charge assembly does neither, which gives
//     reverse-mode terminal mixing and negative PMOS capacitances (b1ld.c
//     ceqbs/ceqbd/ceqqg and the B1mosCap argument+output swap).
//   * Model-level TEMP (degC) from the doc's Process Parameters table has no
//     home here: Verilog-A cannot carry two `temp` parameters, and no equation
//     consumes it -- the instance TEMP (K) that feeds Vt wins.
//   * fetlim/limvds/pnjlim are spelled with $limit as in mos1.va, all with the
//     trailing frame-sign argument — a $limit under `if (type > 0)` is silently
//     declined (no CFG in the clamp list), which is exactly what the old
//     per-polarity spelling was.
module bsim1(d, g, s, b);
    inout d, g, s, b;
    electrical d, g, s, b;
    electrical di, si;

    // ---- threshold ---------------------------------------------------------
    parameter real vfb  = 0.0;   parameter real lvfb = 0.0;   parameter real wvfb = 0.0;
    parameter real phi  = 0.0;   parameter real lphi = 0.0;   parameter real wphi = 0.0;
    parameter real k1   = 0.0;   parameter real lk1  = 0.0;   parameter real wk1  = 0.0;
    parameter real k2   = 0.0;   parameter real lk2  = 0.0;   parameter real wk2  = 0.0;

    // ---- DIBL --------------------------------------------------------------
    parameter real eta  = 0.0;   parameter real leta = 0.0;   parameter real weta = 0.0;
    parameter real x2e  = 0.0;   parameter real lx2e = 0.0;   parameter real wx2e = 0.0;
    parameter real x3e  = 0.0;   parameter real lx3e = 0.0;   parameter real wx3e = 0.0;

    // ---- mobility ----------------------------------------------------------
    parameter real muz  = 0.0;
    parameter real x2mz = 0.0;   parameter real lx2mz = 0.0;  parameter real wx2mz = 0.0;
    parameter real mus  = 0.0;   parameter real lmus  = 0.0;  parameter real wmus  = 0.0;
    parameter real x2ms = 0.0;   parameter real lx2ms = 0.0;  parameter real wx2ms = 0.0;
    parameter real x3ms = 0.0;   parameter real lx3ms = 0.0;  parameter real wx3ms = 0.0;
    parameter real u0   = 0.0;   parameter real lu0   = 0.0;  parameter real wu0   = 0.0;
    parameter real x2u0 = 0.0;   parameter real lx2u0 = 0.0;  parameter real wx2u0 = 0.0;
    parameter real u1   = 0.0;   parameter real lu1   = 0.0;  parameter real wu1   = 0.0;
    parameter real x2u1 = 0.0;   parameter real lx2u1 = 0.0;  parameter real wx2u1 = 0.0;
    parameter real x3u1 = 0.0;   parameter real lx3u1 = 0.0;  parameter real wx3u1 = 0.0;

    // ---- subthreshold slope ------------------------------------------------
    parameter real n0 = 0.0;     parameter real ln0 = 0.0;    parameter real wn0 = 0.0;
    parameter real nb = 0.0;     parameter real lnb = 0.0;    parameter real wnb = 0.0;
    parameter real nd = 0.0;     parameter real lnd = 0.0;    parameter real wnd = 0.0;

    // ---- process -----------------------------------------------------------
    parameter real tox = 0.0 from [0:inf);   // um
    parameter real dl  = 0.0;                // um
    parameter real dw  = 0.0;                // um
    parameter real ld  = 0.0;                // m, lateral diffusion (geometry bookkeeping)
    parameter real vdd = 0.0;                // V, reference bias for MUS

    // ---- series resistance and junctions -----------------------------------
    parameter real rsh  = 0.0 from [0:inf);
    parameter real nrd  = 1.0 from [0:inf);   // squares of drain diffusion
    parameter real nrs  = 1.0 from [0:inf);   // squares of source diffusion
    parameter real js   = 0.0;
    parameter real pb   = 0.1;
    parameter real mj   = 0.0;
    parameter real pbsw = 0.1;
    parameter real mjsw = 0.0;
    parameter real cj   = 0.0;
    parameter real cjsw = 0.0;
    parameter real wdf  = 0.0;   // um
    parameter real dell = 0.0;   // um

    // ---- overlap caps ------------------------------------------------------
    parameter real cgso = 0.0;
    parameter real cgdo = 0.0;
    parameter real cgbo = 0.0;

    // ---- noise coefficients (carried for the noise contract) ---------------
    parameter real kf = 0.0;
    parameter real af = 1.0;

    // ---- flags and instance ------------------------------------------------
    parameter integer xpart = 0 from [0:1];             // 0 = 40/60, 1 = 0/100
    parameter integer type  = 1 from [-1:1] exclude 0;  // 1 = NMOS, -1 = PMOS
    parameter real w    = 5e-6   from (0:inf);
    parameter real l    = 5e-6   from (0:inf);
    parameter real temp = 300.15 from (0:inf);          // K
    parameter real m    = 1.0    from (0:inf);

    // geometry / setup
    real leff, weffr, lum, wum, wm, toxcm, cox, coxp, bfac, wlcox;
    real vfbe, phie, k1e, k2e, etae, x2ee, x3ee;
    real x2mze, muse, x2mse, x3mse, u0e, x2u0e, u1e, x2u1e, x3u1e;
    real n0e, nbe, nde;
    real bz0, bzb, bvd, bvdb, bvdd_d, bvds0, bvdd;
    real gdcond, gscond, adrain, asource, pdrain, psource, isd, iss, vtherm;
    real pbc, pbswc, czbs, czbssw, czbd, czbdsw, vcrits, vcritd;
    real tyf, vtx;
    // bias
    real vdst, vgst, vgdt, vbst, vds, vdsneg, vgs, vbs, vbsj, vbdj, mode, uj;
    real ibs, ibd, ugse, udsr, udss, etac, vpb, sqvpb, von, vgov;
    real gfac, afac, arg, beta0, beta, c1, c2, vc, kfac, vdsat;
    real vdse, argl1, argl2, idmain, nsub, wds, wgs, iw0, ilim, isub, idchan;
    real gmnoi, gmsub;
    real vth0, vgst0, qgsat, qbsat, qdsat, qbs, qbd, qdi;

    analog begin
        // ================= bias-independent setup ==========================
        leff  = max(l - dl * 1e-6, 1e-9);
        weffr = max(w, 1e-9);
        lum   = max(leff * 1e6, 0.01);
        wum   = max(weffr * 1e6 - dw, 0.01);
        wm    = max(weffr - dw * 1e-6, 1e-8);

        toxcm = tox > 0.0 ? tox * 1e-4 : 1e-5;
        cox   = 3.453e-13 / toxcm;              // F/cm^2
        coxp  = cox * 1e4;                      // F/m^2, for the flicker PSD

        // P_eff = P0 + LP/Leff_um + WP/Weff_um
        vfbe  = vfb  + lvfb  / lum + wvfb  / wum;
        phie  = max(phi + lphi / lum + wphi / wum, 0.1);
        k1e   = k1   + lk1   / lum + wk1   / wum;
        k2e   = k2   + lk2   / lum + wk2   / wum;
        etae  = eta  + leta  / lum + weta  / wum;
        x2ee  = x2e  + lx2e  / lum + wx2e  / wum;
        x3ee  = x3e  + lx3e  / lum + wx3e  / wum;
        x2mze = x2mz + lx2mz / lum + wx2mz / wum;
        muse  = mus  + lmus  / lum + wmus  / wum;
        x2mse = x2ms + lx2ms / lum + wx2ms / wum;
        x3mse = x3ms + lx3ms / lum + wx3ms / wum;
        u0e   = u0   + lu0   / lum + wu0   / wum;
        x2u0e = x2u0 + lx2u0 / lum + wx2u0 / wum;
        u1e   = u1   + lu1   / lum + wu1   / wum;
        x2u1e = x2u1 + lx2u1 / lum + wx2u1 / wum;
        x3u1e = x3u1 + lx3u1 / lum + wx3u1 / wum;
        n0e   = n0   + ln0   / lum + wn0   / wum;
        nbe   = nb   + lnb   / lum + wnb   / wum;
        nde   = nd   + lnd   / lum + wnd   / wum;

        // CoxWoverL = Cox[F/cm^2] * Weff/Leff [um/um] — b1temp.c:81 has no
        // further unit factor (mobility is cm^2/Vs, so muz*bfac is A/V^2),
        // and only the five beta interpolation params are scaled by it
        // (b1temp.c:134-138). The U0/U1 families stay raw 1/V (b1eval.c:159-173).
        bfac   = cox * (wum / lum);
        bz0    = muz   * bfac;      // beta at Vds=0, Vbs=0
        bzb    = x2mze * bfac;
        bvd    = muse  * bfac;      // beta at Vds=Vdd
        bvdb   = x2mse * bfac;
        // b1temp.c:138 MAXes the scaled dBeta/dVds at zero (b1eval.c:219 MAXes
        // it a second time): a negative X3MS must not tilt Beta0 downward.
        bvdd_d = max(x3mse * bfac, 0.0);

        // G = 1/(RSH*NR), per side; zero means "collapse d'->d" below.
        gdcond  = (rsh > 0.0 && nrd > 0.0) ? m / (rsh * nrd) : 0.0;
        gscond  = (rsh > 0.0 && nrs > 0.0) ? m / (rsh * nrs) : 0.0;
        asource = wdf > 0.0 ? wdf * dell : wm * 1e-6;
        adrain  = asource;
        psource = 2.0 * wm;
        pdrain  = psource;
        iss     = max(asource * js, 1e-15);
        isd     = max(adrain  * js, 1e-15);
        vtherm  = 8.617333262145e-5 * temp;
        vcrits  = vtherm * ln(vtherm / (1.4142135623730951 * iss));
        vcritd  = vtherm * ln(vtherm / (1.4142135623730951 * isd));
        tyf     = type;                     // $limit args must be real-typed
        vtx     = vfbe + phie + k1e * sqrt(phie) - k2e * phie;  // zero-bias von

        // b1temp.c clamps both potentials at 0.1 (the doc table's 0.01 is wrong,
        // and a 0.01 floor blows up the czb*mj/pbc charge coefficients).
        pbc    = max(pb,   0.1);
        pbswc  = max(pbsw, 0.1);
        czbs   = cj   * asource;
        czbssw = cjsw * psource;
        czbd   = cj   * adrain;
        czbdsw = cjsw * pdrain;

        wlcox = cox * leff * wm * 1e4;

        // ================= bias-dependent ==================================
        // type folding + source/drain swap: Vds is made positive, the gate and
        // bulk references move to the true source, and `mode` carries the sign
        // back to the channel stamp. mos1.va's §1.7 ladder on the way in:
        // fetlim both gate legs, limvds the channel; trailing tyf = VerA frame
        // sign (PMOS limits type*v).
        vgst = tyf * $limit(V(g, si), "fetlim", vtx, tyf);
        vgdt = tyf * $limit(V(g, di), "fetlim", vtx, tyf);
        vdst = tyf * $limit(V(di, si), "limvds", tyf);
        vgdt = vgst - vdst;
        vbst = V(b,  si) * type;

        vds    = abs(vdst);
        vdsneg = min(vdst, 0.0);
        mode   = vdst >= 0.0 ? 1.0 : -1.0;
        vgs    = vgst - vdsneg;
        vbs    = vbst - vdsneg;

        // Bulk junctions: mode-free, on the TRUE junction voltages, Newton-limited
        // with pnjlim (V_crit = Vt*ln(Vt/(sqrt(2)*Is)) per doc); the trailing tyf
        // = VerA frame sign, so PMOS limits type*v with no per-polarity if (a
        // $limit under `if` is silently declined). The swapped vbs above stays
        // for the channel block only -- feeding it here would stamp the source
        // diode onto d' whenever V(di,si) < 0. Exponent tangent-continued above
        // 80: a flat clamp zeroes the restoring slope on evals at unlimited x
        // (LTE probes, sweep warm starts; see bjt.va pnj).
        vbsj = tyf * $limit(V(b, si), "pnjlim", vtherm, vcrits, tyf);
        vbdj = tyf * $limit(V(b, di), "pnjlim", vtherm, vcritd, tyf);
        uj  = min(vbsj / vtherm, 80.0);
        ibs = iss * (exp(uj) * (1.0 + (vbsj / vtherm - uj)) - 1.0) + 1e-12 * vbsj;
        uj  = min(vbdj / vtherm, 80.0);
        ibd = isd * (exp(uj) * (1.0 + (vbdj / vtherm - uj)) - 1.0) + 1e-12 * vbdj;

        // bias-dependent mobility / DIBL coefficients
        ugse = max(u0e + x2u0e * vbs, 0.0);
        udsr = u1e + x2u1e * vbs + x3u1e * (vds - vdd);
        udss = max(udsr, 0.0) / lum;
        etac = min(max(etae + x2ee * vbs + x3ee * (vds - vdd), 0.0), 1.0);

        // threshold
        vpb   = phie - min(vbs, 0.0);
        sqvpb = sqrt(max(vpb, 0.001));
        von   = vfbe + phie + k1e * sqvpb - k2e * vpb - etac * vds;
        vgov  = vgs - von;

        // bulk-charge factor
        gfac = 1.0 - 1.0 / (1.744 + 0.8364 * vpb);
        afac = max(1.0 + gfac * k1e / (2.0 * sqvpb), 1.0);
        arg  = max(1.0 + ugse * vgov, 1.0);

        // beta vs Vds, b1eval.c:217-235: quadratic interpolation between the
        // Vds=0 endpoint (MUZ) and the Vds=VDD endpoint (MUS) below VDD, and a
        // LINEAR EXTRAPOLATION OFF THE **MUS** ENDPOINT above it. The branch is
        // on `vds > Vdd`, not on whether VDD was given -- with the ngspice
        // default VDD = 0 (b1set.c:194) every vds > 0 takes the extrapolation
        // branch, so a card that also leaves MUS at its 0 default (b1set.c:80)
        // has NO strong-inversion current at all and the whole curve is the
        // subthreshold limiter below. Guarding on `vdd > 0` instead kept the MUZ
        // endpoint and overstated devices/bsim1's i(vds) by 2.1e3.
        // vdd == 0 makes b1eval.c's else-branch divide by zero (Beta0 = NaN,
        // then MAX(NaN,0) = 0); vds is 0 in that case too, so holding the Vds=0
        // endpoint gives the same current without the NaN.
        bvds0 = bz0 + bzb  * vbs;                // Beta_Vds_0
        bvdd  = bvd + bvdb * vbs;                // BetaVdd
        if (vds > vdd) begin
            beta0 = bvdd + bvdd_d * (vds - vdd);
        end else if (vdd > 0.0) begin
            c1    = (-bvdd + bvds0 + bvdd_d * vdd) / (vdd * vdd);
            c2    = 2.0 * (bvdd - bvds0) / vdd - bvdd_d;
            beta0 = (c1 * vds + c2) * vds + bvds0;
        end else begin
            beta0 = bvds0;
        end
        beta = beta0 / arg;

        // saturation voltage
        vc    = max(udss * vgov / afac, 0.0);
        kfac  = 0.5 * (1.0 + vc + sqrt(1.0 + 2.0 * vc));
        vdsat = max(vgov / (afac * sqrt(kfac)), 0.0);

        // Strong-inversion current. b1eval.c has NO channel-length modulation:
        // above Vdsat the current is flat at 0.5*Beta*Vgs_Vth^2/(A*K)
        // (b1eval.c:276-278), and the triode expression evaluated at vds = Vdsat
        // IS that value -- with s = sqrt(K) = (1 + sqrt(1+2*Vc))/2 one has
        // s + Vc = s*(2s-1), so triode(Vdsat)/sat = (2s-1)/(1 + Vc/s) = 1. The
        // `1 + Uds*(vds - Vdsat)` factor that used to sit here is not in the C.
        vdse   = min(vds, vdsat);
        argl1  = max(1.0 + udss * vdse, 1.0);
        argl2  = max(vgov, 0.0) - 0.5 * afac * vdse;
        idmain = beta * argl2 * vdse / argl1;

        // subthreshold, parallel-limited to 4.5*Vt^2*beta0(0,0)
        isub  = 0.0;
        gmsub = 0.0;
        if (n0e < 200.0 && bz0 > 0.0) begin
            nsub = max(n0e + nbe * vbs + nde * vds, 0.5);
            wds  = 1.0 - exp(-min(max(vds / vtherm, 0.0), 80.0));
            wgs  = exp(min(vgov / (nsub * vtherm), 80.0));
            iw0  = 6.04965 * vtherm * vtherm * bz0 * wgs * wds;
            ilim = 4.5 * vtherm * vtherm * bz0;
            isub = ilim * iw0 / (ilim + iw0);
            gmsub = (ilim / (ilim + iw0)) * (ilim / (ilim + iw0))
                    * iw0 / (nsub * vtherm);
        end

        idchan = max(idmain + isub, 0.0);

        // gm, for the channel/flicker noise PSDs only (the AD backend owns the
        // Jacobian). ponytail: d(Id)/d(Vgs) of the triode/CLM core, dropping the
        // weak beta(vgov) and Vdsat(vgov) terms; refine if noise fixtures care.
        gmnoi = (vgov > 0.0 ? beta * vdse / argl1 : 0.0) + gmsub;

        // ================= charges =========================================
        // Intrinsic 40/60 (or 0/100) saturation charges, in the swapped frame
        // like the channel current.
        vth0  = vfbe + phie + k1e * sqvpb;          // threshold without DIBL
        vgst0 = vgs - vth0;
        qgsat = wlcox * (vgs - vfbe - phie - vgst0 / (3.0 * afac));
        qbsat = wlcox * (vfbe + phie - vth0 + (1.0 - afac) * vgst0 / (3.0 * afac));
        qdsat = (xpart != 0) ? 0.0 : -(4.0 / 15.0) * wlcox * vgst0;

        // Un-swap: the intrinsic drain charge belongs to the true drain, so with
        // V(di,si) < 0 node d' carries the swapped-source charge instead
        // (= -(Qg+Qb+Qd), b1ld.c's B1mosCap output swap).
        // ponytail: only the saturation partition exists (doc has no triode
        // branch), so this exchange steps at Vds=0; port B1mosCap's triode
        // partition if a transient fixture trips on it.
        qdi = (mode > 0.0) ? qdsat : -(qgsat + qbsat + qdsat);

        // Junction depletion charges, on the true (typed) junction voltages.
        qbs = vbsj * (czbs + czbssw) +
              0.5 * vbsj * vbsj * (czbs * mj / pbc + czbssw * mjsw / pbswc);
        qbd = vbdj * (czbd + czbdsw) +
              0.5 * vbdj * vbdj * (czbd * mj / pbc + czbdsw * mjsw / pbswc);

        // ================= KCL =============================================
        // Series resistances, or node collapse when RSH*NR is zero.
        if (gdcond > 0.0) begin
            I(d, di) <+ gdcond * V(d, di)
                      + white_noise(4.0 * 1.380649e-23 * temp * gdcond, "rd");
        end else begin
            V(d, di) <+ 0.0;
        end
        if (gscond > 0.0) begin
            I(s, si) <+ gscond * V(s, si)
                      + white_noise(4.0 * 1.380649e-23 * temp * gscond, "rs");
        end else begin
            V(s, si) <+ 0.0;
        end

        // Channel (sign follows the swap) and bulk diodes (type-folded).
        I(di, si) <+ mode * type * m * idchan;
        I(b, di)  <+ m * type * ibd;
        I(b, si)  <+ m * type * ibs;

        // Overlap charges: written on the true node voltages, where the two type
        // factors cancel, so they are both mode- and PMOS-safe.
        I(g, si) <+ m * ddt(cgso * wm   * V(g, si));
        I(g, di) <+ m * ddt(cgdo * wm   * V(g, di));
        I(g, b)  <+ m * ddt(cgbo * leff * V(g, b));

        // Intrinsic + junction charges: type-folded on the way out (b1ld.c
        // ceqqg/ceqqb/ceqqd), referenced to s' so q(s') = -(qg+qb+qd') holds.
        I(g,  si) <+ m * type * ddt(qgsat);
        I(b,  si) <+ m * type * ddt(qbsat + qbs);
        I(b,  di) <+ m * type * ddt(qbd);
        I(di, si) <+ m * type * ddt(qdi);

        // Noise (mos-legacy.md noise table, mos1noi.c template; Cox'^2 denom).
        I(di, si) <+ white_noise(4.0 * 1.380649e-23 * temp * (2.0 / 3.0) * abs(gmnoi),
                                 "channel");
        if (kf > 0.0) begin
            I(di, si) <+ flicker_noise(kf * pow(abs(idchan), af)
                                       / (wm * m * leff * coxp * coxp), 1.0, "flicker");
        end
    end
endmodule
