// Coupled lossy transmission lines, two conductors: even/odd modal
// decomposition into two Bergeron lines with lumped loss.
//
// Verilog-A implementation: Omar El-Sawy, University of Waterloo.
// Based on: ngspice P element / CPL (cpl/cplsetup.c, cplload.c).
//   ngspice: Copyright Regents of the University of California and others,
//   modified BSD license.
//
// Approximate model kept for comparison; P cards use the native CPL model
// (models/native/coupled_ltra.zig). See
// docs/native-transmission-line-migration.md. It omits the native modal
// fitting and recursive convolution, so it is not exact even for two
// conductors.
//
// A symmetric pair has fixed even/odd eigenvectors Sv = Si = [[1,1],[1,-1]].
// Card order matches ngspice: conductors of port 1, its return, conductors of
// port 2, its return (`P1 a1 a2 0 b1 b2 0 pline`). Per-unit-length matrices
// are the upper triangle as ngspice spells it (R = r rm r, L = l lm l, ...):
// self term `x`, mutual term `xm`, modes X_e = x + xm, X_o = x - xm.
//
// Deliberate differences from ngspice:
//  1. The DC series resistance is the full matrix product (R*length*i)_m,
//     mutual included: v_p1 - v_n1 = length*(r*i1 + rm*i2). ngspice's cond1
//     row loop picks only R_mm. Identical on rm = 0 cards.
//  2. Shunt loss G acts only as transient wave attenuation (alpha = G*Z/2).
//     With no shunt path for the removed current, the transient steady state
//     sits slightly below the exact DC point. ponytail: an explicit
//     g*length/2 shunt at each end needs internal nodes; add it if a
//     G-dominated card shows up.
module coupled_tlines(p1, p2, pr, n1, n2, nr);
    inout p1, p2, pr, n1, n2, nr;
    electrical p1, p2, pr, n1, n2, nr;

    // Conductor branches, each against its own common return. I(bk) is the
    // current into the line, V(bk) the port voltage of that conductor.
    branch (p1, pr) b1;
    branch (p2, pr) b2;
    branch (n1, nr) b3;
    branch (n2, nr) b4;

    // ngspice `dimension` (cpl.c CPL_DIM). This topology is the 2-conductor
    // case, so any other value is a bind-time range error. `[2:3)` because
    // LRM 3.4.2 forbids a single-value `[2:2]` range; on an integer it is the
    // same set.
    parameter integer dimension = 2 from [2:3);

    // Per-unit-length RLGC. ngspice floors out-of-range entries instead of
    // rejecting them (see rc/rmc below). ngspice has no defaults and requires
    // R, L, G, C and length (cplsetup.c E_BADPARM); Verilog-A cannot require a
    // parameter, so l/c/length default to a 50 ohm, 1 m line and the check
    // lives in the P-card mapping (src/frontend/builder.zig).
    parameter real r      = 0.0     from [0:inf);  // ohm/m
    parameter real rm     = 0.0;                   // ohm/m
    parameter real l      = 250e-9  from (0:inf);  // H/m
    parameter real lm     = 0.0;                   // H/m
    parameter real g      = 0.0     from [0:inf);  // S/m
    parameter real gm     = 0.0;                   // S/m
    parameter real c      = 100e-12 from (0:inf);  // F/m  (Maxwell form: cm < 0)
    parameter real cm     = 0.0;                   // F/m
    parameter real length = 1.0     from (0:inf);  // m

    // 0.1*gmin conditioning on all port diagonals (cplload.c).
    parameter real gmin   = 1e-12   from [0:inf);

    // Modal line constants (parameters only).
    real rc, rmc, lmc, cmc, gmc;
    real le, lo, ce, co, ze, zo, te, to, re, ro, ae, ao;
    // Modal port variables and outgoing waves.
    real ve1, vo1, ie1, io1, we1, wo1;
    real ve2, vo2, ie2, io2, we2, wo2;
    real xe1, xo1, xe2, xo2;

    analog begin
        // ngspice floors every R entry, self and mutual, at 1e-4 ohm/m
        // (cplsetup.c `MAX(f, 1.0e-4)`), so R is never singular; r = 0 runs as
        // 1e-4.
        rc  = max(r,  1e-4);
        rmc = max(rm, 1e-4);

        // Physical coupling obeys |xm| < x. Clamping the mutual to a coupling
        // coefficient of 0.999 keeps the odd mode positive-definite (no
        // sqrt(<=0)) and the forced step near the nominal delay, so a bad
        // card runs slow instead of stalling. ponytail: 0.999 is a guard, not
        // a model knob; rejection belongs to the dimension range and the
        // P-card mapping.
        lmc = max(min(lm, 0.999 * l), -0.999 * l);
        cmc = max(min(cm, 0.999 * c), -0.999 * c);
        gmc = max(min(gm, 0.999 * g), -0.999 * g);

        le = l + lmc;
        lo = l - lmc;
        ce = c + cmc;
        co = c - cmc;

        ze = sqrt(le / ce);
        zo = sqrt(lo / co);
        te = length * sqrt(le * ce);
        to = length * sqrt(lo * co);

        // At DC the line collapses to its series resistance R*length. Half of
        // each modal R*length sits at each end, folded into the Bergeron
        // termination; 2*re / 2*ro are the full modal DC resistances. ro is
        // floored because rm > r would make the odd-mode resistance negative.
        re = 0.5 * length * (rc + rmc);
        ro = 0.5 * length * max(rc - rmc, 1e-4);

        // Shunt loss as modal wave attenuation, alpha = G*Z/2. Transient only:
        // the static rows below are exact, so G cannot shift the DC point.
        ae = exp(-0.5 * length * (g + gmc) * ze);
        ao = exp(-0.5 * length * (g - gmc) * zo);

        // At least one sample per modal delay, as ngspice forces.
        $bound_step(0.9 * min(te, to));

        // Sv^-1 / Si^-1 on the port variables: the even/odd average.
        ve1 = 0.5 * (V(b1) + V(b2));
        vo1 = 0.5 * (V(b1) - V(b2));
        ie1 = 0.5 * (I(b1) + I(b2));
        io1 = 0.5 * (I(b1) - I(b2));
        ve2 = 0.5 * (V(b3) + V(b4));
        vo2 = 0.5 * (V(b3) - V(b4));
        ie2 = 0.5 * (I(b3) + I(b4));
        io2 = 0.5 * (I(b3) - I(b4));

        // Wave leaving each line terminal (port voltage minus the lumped
        // half-R drop, plus the characteristic term).
        we1 = ve1 + (ze - re) * ie1;
        wo1 = vo1 + (zo - ro) * io1;
        we2 = ve2 + (ze - re) * ie2;
        wo2 = vo2 + (zo - ro) * io2;

        if (!analysis("static")) begin
            // Modal port equations: instantaneous characteristic admittance
            // term + the attenuated, tau_m-delayed wave from the far end.
            xe1 = (ze + re) * ie1 + ae * absdelay(we2, te);
            xo1 = (zo + ro) * io1 + ao * absdelay(wo2, to);
            xe2 = (ze + re) * ie2 + ae * absdelay(we1, te);
            xo2 = (zo + ro) * io2 + ao * absdelay(wo1, to);
        end else begin
            // ngspice "DC / cond1", per mode. absdelay is transparent at DC,
            // so the delayed-wave form would fold ae/ao into the DC answer;
            // the exact rows go here instead (same split as lossy_tline.va).
            //
            //   ve1 = ve2 - Rdc*ie2  and  ve2 = ve1 - Rdc*ie1
            //
            // sum  => ie1 + ie2 = 0
            // diff => ve1 - ve2 = Rdc*ie1,  Rdc_e = 2*re, Rdc_o = 2*ro
            //
            // In conductor terms that is exactly (R*length*i)_m:
            //   v_p1 - v_n1 = length*(rc*i1 + rmc*i2).
            xe1 = ve2 - 2.0 * re * ie2;
            xo1 = vo2 - 2.0 * ro * io2;
            xe2 = ve1 - 2.0 * re * ie1;
            xo2 = vo1 - 2.0 * ro * io1;
        end

        // Si transform back to conductors (v1 = v_e + v_o, v2 = v_e - v_o).
        V(b1) <+ xe1 + xo1;
        V(b2) <+ xe1 - xo1;
        V(b3) <+ xe2 + xo2;
        V(b4) <+ xe2 - xo2;

        // ngspice adds 0.1*CKTgmin to posPos/negNeg/negPos/posNeg for every
        // conductor (cplload.c), a tiny conductance end-to-end across each
        // conductor. Every other branch here is voltage-defined.
        I(p1, n1) <+ 0.1 * gmin * V(p1, n1);
        I(p2, n2) <+ 0.1 * gmin * V(p2, n2);
    end
endmodule
