// Lossy transmission line (LTRA), partial: exact for LC and RG, DC-exact
// approximation for RLC, DC-only for RC.
//
// Verilog-A implementation: Omar El-Sawy, University of Waterloo.
// Based on: ngspice O element / LTRA (ltra/ltraload.c, ltraset.c), the
//   Roychowdhury-Pederson convolution line model (DAC'91).
//   ngspice: Copyright Regents of the University of California and others,
//   modified BSD license.
//
// O-card RLC/RC devices use the native convolution model
// (models/native/ltra_native.zig); LC uses tline.va. This file is kept for
// comparison and the static RG path. Migration requirements:
// docs/native-transmission-line-migration.md.
//
// Each port has one branch-current unknown (ngspice rows brEq1/brEq2), i1 and
// i2 both flowing INTO the line:
//
//     Y0*v1 + Y0*(h1'*v1) - i1 = (h2*i2) + Y0*(h3'*v2)      (port 2 symmetric)
//
// Multiplied by Z0 = 1/Y0 this is a potential relation a Verilog-A branch can
// stamp: v_i = Z0*i_i + <history>.
//
// Supported cards (ltraset.c rejects the rest with E_BADPARM; here $error):
//   LC  (R=0, G=0, L>0, C>0)   exact: pure delay T = len*sqrt(L*C)
//   RLC (R>0, G=0, L>0, C>0)   delay + loss, see "Loss" below
//   RC  (R>0, G=0, L=0, C>0)   DC series resistance only
//   RG  (R>0, G>0, L=C=0)      exact hyperbolic two-port
//
// Not implemented: the h1'/h2/h3' convolutions, accepted-history storage,
// coefficient rebuilds, compaction and quadratic interpolation. They need an
// accepted-point callback (VPI acbAcceptedPoint); Verilog-A has no accepted
// step event. So the RC branch lacks its transient erfc dispersion and must
// not replace the native RC route.
//
// Loss (RLC): the result must stay exact at DC (i1 + i2 = 0,
// v1 - v2 = R*len*i1), because that is the operating point the transient
// continues from. Attenuating only the travelling wave, A = exp(-beta*T),
// yields a spurious common-mode conductance (1-A)(v1+v2) = Z0(1+A)(i1+i2) and
// half the DC differential resistance. Instead R*len is split into
// Rh = R*len/2 in series at each port around a lossless Branin core:
//
//     v1 = (Z0 + Rh)*i1 + [v2 + (Z0 - Rh)*i2](t-T)          (port 2 symmetric)
//
// Sum and difference of the two rows are ngspice's MODEDC rows (ltraload.c:
// brEq1 <- Ibr1 + Ibr2, brEq2 <- pos1 - pos2 - R*len*Ibr1). The network is
// passive for every R (|Z0-Rh| < Z0+Rh); matched at both ends, the first
// transit arrives attenuated by 1/(1 + beta*T/2)^2 = exp(-beta*T) + O((beta*T)^2)
// with beta*T = R*len/(2*Z0). It omits the Bessel dispersion tail and adds end
// reflections off Rh, so it does not meet the native-device migration gate.
//
// absdelay is not guarded by analysis("static"): LRM §4.5.6 makes it return
// its input in DC/OP and hold Input(0) for t < T, which is ngspice's
// initVolt/initCur snapshot and yields the DC rows for LC (R = 0), where a
// static hyperbolic stamp would give V(br1)-V(br2) = 0 twice.
//
// The `.model ltra` keywords are declared for card compatibility; only the
// step-limit flags act. Noise: none (ngspice has no ltranoise.c).
module lossy_tline(p1, n1, p2, n2);
    inout p1, n1, p2, n2;
    electrical p1, n1, p2, n2;

    // One branch per port; its flow is the MNA branch-current unknown.
    branch (p1, n1) br1;
    branch (p2, n2) br2;

    // Per-unit-length RLGC and length. A parameter cannot lack a default
    // (LRM A.2.3), so len = 0 marks "not given" and the analog initial block
    // enforces ngspice's required length and valid R,L,G,C combination.
    parameter real r   = 0.0 from [0:inf);
    parameter real l   = 0.0 from [0:inf);
    parameter real g   = 0.0 from [0:inf);
    parameter real c   = 0.0 from [0:inf);
    parameter real len = 0.0 from [0:inf);   // REQUIRED [m]

    // Remaining `.model ltra` keywords (ltra.c IOP table) with ltraset.c's
    // effective defaults. Only steplimit/nosteplimit act. `abs` (REAL,
    // default 1) is a reserved word (LRM §4.3), so it needs a host-side alias.
    parameter real rel           = 1.0   from (0:inf);  // LTE reltol
    parameter real compactrel    = 1e-3  from [0:inf);  // CKTreltol
    parameter real compactabs    = 1e-12 from [0:inf);  // CKTabstol
    parameter integer nocontrol    = 1 from [0:1];      // lteConType (default)
    parameter integer steplimit    = 1 from [0:1];      // dt <= nl*T (default)
    parameter integer nosteplimit  = 0 from [0:1];
    parameter integer lininterp    = 0 from [0:1];      // howToInterp
    parameter integer quadinterp   = 1 from [0:1];      // default
    parameter integer mixedinterp  = 0 from [0:1];
    parameter integer truncnr      = 0 from [0:1];
    parameter integer truncdontcut = 0 from [0:1];

    // Step cap as a fraction of the delay: an ngspice constant, not a card
    // keyword (LRM §3.4.5).
    localparam real nl = 0.25;

    // LC/RLC take the delay form, RC/RG the hyperbolic two-port. Constant for
    // the run, so legal around an analog operator.
    localparam integer wave = (g == 0.0) && (l > 0.0) && (c > 0.0);
    localparam integer ok = wave
        || ((r > 0.0) && (g == 0.0) && (l == 0.0) && (c > 0.0))    // RC
        || ((r > 0.0) && (g > 0.0) && (l == 0.0) && (c == 0.0));   // RG

    real z0, td, rh;         // sqrt(L/C), T, R*len/2
    real gl, sinhc, ch, zs;  // hyperbolic two-port

    // $error in an analog initial block stops the run after initialization
    // (LRM §9.7.3), ngspice's E_BADPARM.
    analog initial begin
        if (len <= 0.0)
            $error("lossy_tline: lossy line length must be given (len > 0)");
        if (!ok)
            $error("lossy_tline: unsupported r/l/g/c set; supported: LC, RLC, RC (r,c>0, l=g=0), RG (r,g>0, l=c=0). RL and general G are rejected, and at least two of r,l,g,c must be nonzero.");
    end

    analog begin
        if (wave) begin
            // Rh = 0 for LC gives the plain Branin line.
            z0 = sqrt(l / c);
            td = len * sqrt(l * c);
            rh = 0.5 * r * len;

            // stepLimit: an edge launched now must be resolvable at t+T.
            // td > 0 guards an invalid card, which evaluates this block once
            // before $error stops the run; a zero step bound would hang.
            if (steplimit && !nosteplimit && (td > 0.0))
                $bound_step(nl * td);

            V(br1) <+ (z0 + rh) * I(br1) + absdelay(V(br2) + (z0 - rh) * I(br2), td);
            V(br2) <+ (z0 + rh) * I(br2) + absdelay(V(br1) + (z0 - rh) * I(br1), td);
        end else begin
            // v1 = cosh(gl)*v2 - sqrt(R/G)*sinh(gl)*i2 and the mirror row.
            // Exact for RG; for RC (G = 0) cosh -> 1, zs -> R*len.
            gl = len * sqrt(r * g);
            sinhc = (gl > 1e-9) ? sinh(gl) / gl : 1.0 + gl * gl / 6.0;
            ch = cosh(gl);
            // sqrt(R/G)*sinh(gl) == R*len*sinh(gl)/gl. (1+gmin) applies to the
            // RG stamp only.
            zs = r * len * sinhc;
            if (g > 0.0)
                zs = zs * (1.0 + $simparam("gmin", 1e-12));
            V(br1) <+ ch * V(br2) - zs * I(br2);
            V(br2) <+ ch * V(br1) - zs * I(br1);
        end
    end
endmodule
