// Resistor: linear, i(p,n) = V(p,n) / R(T), with thermal noise.
//
// Verilog-A implementation: Omar El-Sawy, University of Waterloo.
// Based on: ngspice resistor (res/restemp.c RESupdate_conduct, resnoise.c).
//   ngspice: Copyright Regents of the University of California and others,
//   modified BSD license.
//
// Temperature (restemp.c):
//   dt     = (temp + dtemp) - tnom
//   factor = 1 + tc1*dt + tc2*dt^2,  or 1.01^(tce*dt) when tce is given
// tce REPLACES the polynomial. Instance `temp` is an absolute override of the
// circuit temperature; `dtemp` is added to whichever wins. `tnom` is the host's
// `.options tnom`.
//
// Geometry (rsh, narrow, short, defw) and the `scale`/`m` factors are resolved
// by the host (frontend builder addPassive) before the value reaches `r`;
// declaring them here would apply `scale`/`m` twice.
//
// Noise (resnoise.c): thermal S_i = 4kT/R across the terminals. The host
// derives the PSD from the branch conductance as 4kT*g, which for a linear
// resistor is the same number; the declaration is what installs the generator.
//
// `noisy=0` (ngspice; `noise=0` there and in HSPICE, through the host's
// alias table in device/bind.zig) turns the generator off.
//
// ponytail: no flicker noise (resnoise.c, gated on KF, default 0). Add it
// when a deck names it.
module resistor(p, n);
    inout p, n;
    electrical p, n;
    // `r` must stay the first parameter: `.sens`/`.mc` treat the first model
    // parameter as the device's principal one (analysis/eval.zig appendParams),
    // which names the column `v(r1)` as ngspice does.
    parameter real r     = 1000.0 from (0:inf);  // ohm       resistance
    parameter real tnom  = $simparam("tnom");    // degC      nominal temperature
    parameter real temp  = 27.0;                 // degC      absolute override
    parameter real dtemp = 0.0;                  // degC      offset on the above
    parameter real tc1   = 0.0;                  // 1/degC    linear tempco
    parameter real tc2   = 0.0;                  // 1/degC^2  quadratic tempco
    parameter real tce   = 0.0;                  // %/degC    exponential tempco
    parameter integer noisy = 1 from [0:1];      // -         0: noiseless

    real tdev, dt, rt;

    analog begin
        tdev = $temperature - 273.15;
        if ($param_given(temp)) tdev = temp;
        tdev = tdev + dtemp;
        dt = tdev - tnom;
        if ($param_given(tce)) rt = r * pow(1.01, tce * dt);
        else rt = r * (1.0 + dt * (tc1 + tc2 * dt));
        // ponytail: no floor on rt. ngspice clamps the card value (1 mOhm, in
        // the builder) but not the temperature factor, so a tempco that drives
        // the resistance to zero is a NaN here as it is there.
        I(p, n) <+ V(p, n) / rt;
        I(p, n) <+ white_noise(noisy * 4.0 * 1.38064852e-23 * (tdev + 273.15) / rt, "thermal");
    end
endmodule
