// Current-controlled switch (W element, `.model csw`) with four-state hysteresis.
//
// Verilog-A implementation: Omar El-Sawy, University of Waterloo.
// Based on: ngspice W element (csw/cswload.c).
//   ngspice: Copyright Regents of the University of California and others,
//   modified BSD license.
//
// Spec: dev/tline-and-switch.md §1.2 (FSM), §3 (sw_update_state, sw_eval).
// Same FSM as vswitch.va (see its header for the memoryless/latched split);
// only the control quantity differs. A W card names a voltage source
// (`W1 p n vnam csw1`), so the control is the current in the (cp,cn) branch,
// a 0 V ammeter the builder puts in series with that source (see cccs.va).
module cswitch(p, n, cp, cn);
    inout p, n, cp, cn;
    electrical p, n, cp, cn;

    // `V(ctl) <+ vsense` makes I(ctl) a branch-current unknown.
    branch (cp, cn) ctl;

    parameter real it     = 0.0;                  // A    threshold current
    parameter real ih     = 0.0;                  // A    hysteresis half-width
    parameter real ron    = 1.0    from (0:inf);  // ohm  on resistance
    parameter real roff   = 1.0e12 from (0:inf);  // ohm  off resistance (1/gmin)
    parameter real vsense = 0.0;                  // V    ammeter voltage; the builder leaves it 0
    parameter integer ic  = 0;                    //      >0 = start ON

    integer latched;  // held across evaluations: the in-band memory
    integer on;
    real u, hi, lo, gon, goff;

    analog begin
        gon  = 1.0 / ron;
        goff = 1.0 / roff;

        hi = it + abs(ih);
        lo = it - abs(ih);

        V(ctl) <+ vsense;
        u = I(ctl);

        @(initial_step) latched = (ic > 0) ? 3 : 2;

        @(cross(u - hi, +1)) latched = 3;                    // -> HYST_ON
        @(cross(u - lo, -1)) latched = 2;                    // -> HYST_OFF
        @(cross(u - hi, -1)) latched = (ih < 0.0) ? 2 : 3;   // ON rail -> band
        @(cross(u - lo, +1)) latched = (ih < 0.0) ? 3 : 2;   // OFF rail -> band

        if (u > hi) on = 1;
        else if (u < lo) on = 0;
        else on = (latched > 2.5) ? 1 : 0;

        // §3 sw_eval: piecewise-constant stamp, dG/du = 0.
        I(p, n) <+ (on ? gon : goff) * V(p, n);
    end
endmodule
