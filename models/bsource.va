// Behavioral source (B element): polynomial subset over one control pair.
//
// Verilog-A implementation: Omar El-Sawy, University of Waterloo.
// Based on: ngspice B element / ASRC (asrc/asrcload.c, asrc.c).
//   ngspice: Copyright Regents of the University of California and others,
//   modified BSD license.
//
// Spec: docs/passives-and-sources.md §1.6, §3.
//   vc = V(cp,cn)
//   f  = (c0 + c1*vc + c2*vc^2) * (th != 0 ? tanh(th*vc) : 1)
//   V mode (v={...}):  V(p,n) <+ factor*f   (branch-current unknown)
//   I mode (i={...}):  I(p,n) <+ factor*f
// The tanh factor covers the MESFET "ungated load" idiom
// Is*tanh(v/Is/R)*(1+lambda*v); the builder (extractPolyCoeffs) pulls it out
// of the expression tree.
//
// Temperature (asrcload.c): factor = 1 + tc1*dT + tc2*dT^2 with
// dT = (T + dtemp) - 300.15 K (hardcoded, not tnom), inverted when
// reciproctc != 0. tc1/tc2/dtemp/reciproctc are ASRC instance parameters
// (asrc.c ASRCpTable).
//
// ponytail: the polynomial subset is the ceiling. Full expression trees need
// the netlist expression compiled to Verilog-A (or an expression-VM device).
module bsource(p, n, cp, cn);
    inout p, n, cp, cn;
    electrical p, n, cp, cn;

    parameter real c0    = 0.0;      //         constant term
    parameter real c1    = 0.0;      //         linear term
    parameter real c2    = 0.0;      //         square term
    parameter real th    = 0.0;      // 1/V     tanh(th*vc) factor; 0 = none
    parameter real tc1   = 0.0;      // 1/K     linear tempco
    parameter real tc2   = 0.0;      // 1/K^2   quadratic tempco
    parameter real dtemp = 0.0;      // K       offset on the device temperature
    // Instance temperature; <= 0 means "not given", use the circuit
    // temperature (see docs/fastvaf-va-coverage.md on $param_given).
    parameter real temp  = -1.0e3;   // K
    parameter integer reciproctc = 0 from [0:1];
    parameter integer imode      = 0 from [0:1];  // 0 = V output, 1 = I output

    real tdev, dt, factor;
    real k0, k1, k2;
    real vc, f;

    analog begin
        tdev = temp;
        if (temp <= 0.0)
            tdev = $temperature;
        dt = (tdev + dtemp) - 300.15;
        factor = 1.0 + tc1 * dt + tc2 * dt * dt;
        if (reciproctc != 0)
            factor = 1.0 / factor;

        k0 = factor * c0;
        k1 = factor * c1;
        k2 = factor * c2;

        vc = V(cp, cn);
        f = k0 + vc * (k1 + k2 * vc);
        if (th != 0.0)
            f = f * tanh(th * vc);

        if (imode != 0)
            I(p, n) <+ f;
        else if (c0 == 0.0 && c1 == 0.0 && c2 == 0.0)
            // The builder leaves all coefficients at 0 when the expression is
            // outside the polynomial subset. Open circuit, never a hard short
            // (§1.1): a floating node fails loudly, a 0 V source is silently
            // wrong. This costs a literal `v=0` card its short.
            // ponytail: model-side backstop; the real fix is extractPolyCoeffs
            // returning error.UnsupportedDevice when collectTerms() fails.
            I(p, n) <+ 0.0;
        else
            V(p, n) <+ f;
    end
endmodule
