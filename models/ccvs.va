// CCVS: current-controlled voltage source (H element), linear and POLY(1).
//
// Verilog-A implementation: Omar El-Sawy, University of Waterloo.
// Based on: ngspice H element (ccvs/ccvsload.c).
//   ngspice: Copyright Regents of the University of California and others,
//   modified BSD license.
//
// Ports in card order: H<name> p n <vnam> <value>, with (cp,cn) standing in for
// `vnam` exactly as in cccs.va; `vsense` carries the replaced source's DC value.
//
//   linear   H... p n vnam <gain>            V = gain*Ic
//   POLY(1)  H... p n vnam POLY(1) c0 c1 c2  V = c0 + c1*Ic + c2*Ic^2
// The builder fills either `gain` or c0..c2 and leaves the other set at 0, so
// one polynomial covers both; `gain` and `c1` are the same coefficient.
//
// ponytail: one H/F consumer per `vnam` (see cccs.va), and POLY is limited to
// order 2 in one dimension, the same ceiling as bsource.va.
module ccvs(p, n, cp, cn);
    inout p, n, cp, cn;
    electrical p, n, cp, cn;
    branch (p, n) out;
    branch (cp, cn) sense;

    parameter real gain   = 0.0;  // V/A    transresistance (POLY c1)
    parameter real c0     = 0.0;  // V      POLY(1) constant term
    parameter real c1     = 0.0;  // V/A    POLY(1) linear term
    parameter real c2     = 0.0;  // V/A^2  POLY(1) square term
    parameter real vsense = 0.0;  // V      DC value of the replaced control source

    real k1, ic;
    analog begin
        k1 = gain + c1;
        V(sense) <+ vsense;
        ic = I(sense);
        V(out) <+ c0 + k1 * ic + c2 * ic * ic;
    end
endmodule
