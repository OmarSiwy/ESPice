// Statz GaAs MESFET — ngspice `mes` (netlist letter Z, level 1).
// docs/jfet-mesfet-hfet.md: §1.3 is the channel law *and* the Statz `qgg` gate
// charge, §1.5 the temperature / limiting notes, §3 the `.mes` arm of fet_eval,
// the noise table the four mesnoise.c generators.
//
// Topology as in mesload.c: D--RD--di, S--RS--si, two gate junctions g--di and
// g--si, channel current di--si with the normal/inverse swap on sign(vds).
// Limiting (fetlim/limvds/pnjlim, §1.5) is the solver's job, as in diode.va;
// the MODEINITJCT vgs = vgd = -1 V seed likewise has no VA representation
// (FastVAF renders $limit as a pass-through, so writing it would be a no-op).
module mes(d, g, s);
    inout d, g, s;
    electrical d, g, s;
    electrical di, si;                              // channel ends, behind RD/RS
    branch (d, di) brd;
    branch (s, si) brs;

    // +1 = NMF, -1 = PMF.  ngspice carries this in the .model *name*, not as a
    // card parameter; mesload.c applies MEStype to every terminal current.
    parameter integer ztype = 1 from [-1:1] exclude 0;

    parameter real vto    = -2.0;                   // threshold [V]
    parameter real beta   = 2.5e-3  from [0:inf);   // transconductance [A/V^2]
    parameter real b      = 0.3     from [0:inf);   // doping-tail factor [1/V]
    parameter real alpha  = 2.0     from (0:inf);   // knee / saturation [1/V]
    parameter real lambda = 0.0     from [0:inf);   // channel-length mod [1/V]
    parameter real rd     = 0.0     from [0:inf);   // drain resistance [ohm]
    parameter real rs     = 0.0     from [0:inf);   // source resistance [ohm]
    parameter real cgs    = 0.0     from [0:inf);   // zero-bias G-S cap [F]
    parameter real cgd    = 0.0     from [0:inf);   // zero-bias G-D cap [F]
    parameter real pb     = 1.0     from (0:inf);   // gate junction potential [V]
    parameter real is     = 1.0e-14 from (0:inf);   // gate saturation current [A]
    // `fc` is on the ngspice mes card but mesload.c never reads
    // MESdepletionCapCoeff — the Statz qgg charge below has no FC extension.
    // Declared so existing .model lines still parse; deliberately unused.
    parameter real fc     = 0.5     from (0:1);     // forward-bias cap coeff
    parameter real kf     = 0.0     from [0:inf);   // flicker noise coefficient
    parameter real af     = 1.0     from (0:inf);   // flicker noise exponent
    parameter real area   = 1.0     from (0:inf);   // instance area multiplier
    parameter real m      = 1.0     from (0:inf);   // instance parallel multiplier
    parameter real gmin   = 1.0e-12 from [0:inf);   // shunt across each junction

    real vt0, scale, fourkt;
    real vgs, vgd, vds, mode, vx, vdx, arg, igs, igd;
    real vgst, denom, betap, afac, knee, ids, gm;
    real veroot, veff1, veff2, vnroot, vnew, ext, qroot, par1, cfact;
    real cplus, cminus, capgs, capgd;

    analog begin
        // ---- bias-independent prep: no V() below this line touches it ------
        // mesload.c uses the *fixed* CONSTvt0 = k*300.15/q for both gate-diode
        // arms: `mes` has no tnom/temp card parameter and no VTO/BETA/IS
        // temperature maps, so §1.5's family-common maps do not apply here.
        // (The old `tnom` parameter was a unit trap — read as Kelvin while
        // every sibling reads degC — and is gone.)
        vt0    = 1.380649e-23 * 300.15 / 1.602176634e-19;
        scale  = area * m;                          // mesload.c: czxx*area, then m*
        fourkt = 4.0 * 1.380649e-23 * $temperature;

        // Polarity-normalized biases: all math below is NMF (jfet.va pattern).
        vgs = ztype * V(g, si);
        vgd = ztype * V(g, di);
        vds = vgs - vgd;

        // ---- gate junctions, both sides (§3 gate_junction, mesload.c) ------
        // Reverse arm keeps the cubic (1+arg) term that jfetload.c drops:
        // arg = 3*vt0/(v*e), I = -Is*(1+arg^3) + gmin*v below -3*vt0.
        // The exp-argument clamp at 80 is the finite-NR guard from jfet.va:81.
        if (vgs <= -3.0 * vt0) begin
            arg = 3.0 * vt0 / (vgs * 2.718281828459045);
            igs = -is * (1.0 + arg * arg * arg) + gmin * vgs;
        end else begin
            igs = is * (exp(min(vgs / vt0, 80.0)) - 1.0) + gmin * vgs;
        end
        if (vgd <= -3.0 * vt0) begin
            arg = 3.0 * vt0 / (vgd * 2.718281828459045);
            igd = -is * (1.0 + arg * arg * arg) + gmin * vgd;
        end else begin
            igd = is * (exp(min(vgd / vt0, 80.0)) - 1.0) + gmin * vgd;
        end

        // ---- mode select: sign(vds), swap vgs <-> vgd (§3) ----------------
        mode = (vds >= 0.0) ? 1.0 : -1.0;
        vx   = (vds >= 0.0) ? vgs : vgd;
        vdx  = mode * vds;

        // ---- Statz channel, §1.3 -----------------------------------------
        vgst = vx - vto;
        if (vgst <= 0.0) begin                      // cutoff
            ids = 0.0;
            gm  = 0.0;
        end else begin
            betap = beta * (1.0 + lambda * vdx);
            denom = 1.0 + b * vgst;
            if (vdx >= 3.0 / alpha) begin           // saturation
                knee = 1.0;
            end else begin                          // linear: cubic knee
                afac = 1.0 - alpha * vdx / 3.0;
                knee = 1.0 - afac * afac * afac;
            end
            ids = betap * vgst * vgst * knee / denom;
            // mesload.c's gm; only the noise table needs it (2/3*|gm| row).
            gm  = betap * vgst * (2.0 + b * vgst) * knee / (denom * denom);
        end

        // ---- Statz unified gate charge, §1.3 (mesload.c qggnew) ------------
        // One charge qgg = cgs*(2*pb*(1-qroot) + ext) + cgd*veff2 with a smooth
        // vgs/vgd partition driven by alpha and vto, and a vmax = 0.5 clamp
        // above which the sqrt law continues linearly.  capgs/capgd below are
        // exactly dqgg/dvgs and dqgg/dvgd, so the two ddt() stamps sum to
        // ddt(qgg) into the gate: charge-based, not Meyer, and no `fc`.
        veroot = sqrt((vgs - vgd) * (vgs - vgd) + 1.0 / (alpha * alpha));
        veff1  = 0.5 * (vgs + vgd + veroot);
        veff2  = veff1 - veroot;
        vnroot = sqrt((veff1 - vto) * (veff1 - vto) + 0.04);    // del = 0.2
        vnew   = 0.5 * (veff1 + vto + vnroot);
        if (vnew < 0.5) begin                                  // vmax = 0.5
            ext = 0.0;
        end else begin
            ext  = (vnew - 0.5) / sqrt(1.0 - 0.5 / pb);
            vnew = 0.5;
        end
        qroot  = sqrt(1.0 - vnew / pb);
        par1   = 0.5 * (1.0 + (veff1 - vto) / vnroot);
        cfact  = (vgs - vgd) / veroot;
        cplus  = 0.5 * (1.0 + cfact);
        cminus = cplus - cfact;
        capgs  = cgs / qroot * par1 * cplus  + cgd * cminus;
        capgd  = cgs / qroot * par1 * cminus + cgd * cplus;

        // ---- stamps: MEStype * m * area on every branch (mesload.c) --------
        I(g, si)  <+ ztype * scale * igs + ztype * scale * capgs * ddt(vgs);
        I(g, di)  <+ ztype * scale * igd + ztype * scale * capgd * ddt(vgd);
        I(di, si) <+ ztype * scale * mode * ids;

        // ---- noise (doc noise table, mesnoise.c): RD/RS thermal, channel
        //      thermal 2/3|gm|, flicker KF|Id|^AF/f; m rides in via `scale`.
        I(di, si) <+ white_noise(fourkt * (2.0 / 3.0) * abs(gm) * scale, "channel");
        if (kf > 0.0)
            I(di, si) <+ flicker_noise(m * kf * pow(abs(scale * ids), af), 1.0, "flicker");

        // ---- series resistances; a zero one collapses to a short, matching
        //      ngspice building no internal node for it ---------------------
        if (rd > 0.0) begin
            I(brd) <+ scale * V(brd) / rd;
            I(brd) <+ white_noise(fourkt * scale / rd, "rd");
        end else V(brd) <+ 0.0;
        if (rs > 0.0) begin
            I(brs) <+ scale * V(brs) / rs;
            I(brs) <+ white_noise(fourkt * scale / rs, "rs");
        end else V(brs) <+ 0.0;
    end
endmodule
