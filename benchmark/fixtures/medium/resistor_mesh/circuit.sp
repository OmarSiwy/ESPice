* 10x10 resistor mesh (~100 nodes): mid-scale linear DC solve.
V1 n_0_0 0 DC 1
Rh_0_0 n_0_0 n_0_1 100
Rv_0_0 n_0_0 n_1_0 100
Rh_0_1 n_0_1 n_0_2 100
Rv_0_1 n_0_1 n_1_1 100
Rh_0_2 n_0_2 n_0_3 100
Rv_0_2 n_0_2 n_1_2 100
Rh_0_3 n_0_3 n_0_4 100
Rv_0_3 n_0_3 n_1_3 100
Rh_0_4 n_0_4 n_0_5 100
Rv_0_4 n_0_4 n_1_4 100
Rh_0_5 n_0_5 n_0_6 100
Rv_0_5 n_0_5 n_1_5 100
Rh_0_6 n_0_6 n_0_7 100
Rv_0_6 n_0_6 n_1_6 100
Rh_0_7 n_0_7 n_0_8 100
Rv_0_7 n_0_7 n_1_7 100
Rh_0_8 n_0_8 n_0_9 100
Rv_0_8 n_0_8 n_1_8 100
Rv_0_9 n_0_9 n_1_9 100
Rh_1_0 n_1_0 n_1_1 100
Rv_1_0 n_1_0 n_2_0 100
Rh_1_1 n_1_1 n_1_2 100
Rv_1_1 n_1_1 n_2_1 100
Rh_1_2 n_1_2 n_1_3 100
Rv_1_2 n_1_2 n_2_2 100
Rh_1_3 n_1_3 n_1_4 100
Rv_1_3 n_1_3 n_2_3 100
Rh_1_4 n_1_4 n_1_5 100
Rv_1_4 n_1_4 n_2_4 100
Rh_1_5 n_1_5 n_1_6 100
Rv_1_5 n_1_5 n_2_5 100
Rh_1_6 n_1_6 n_1_7 100
Rv_1_6 n_1_6 n_2_6 100
Rh_1_7 n_1_7 n_1_8 100
Rv_1_7 n_1_7 n_2_7 100
Rh_1_8 n_1_8 n_1_9 100
Rv_1_8 n_1_8 n_2_8 100
Rv_1_9 n_1_9 n_2_9 100
Rh_2_0 n_2_0 n_2_1 100
Rv_2_0 n_2_0 n_3_0 100
Rh_2_1 n_2_1 n_2_2 100
Rv_2_1 n_2_1 n_3_1 100
Rh_2_2 n_2_2 n_2_3 100
Rv_2_2 n_2_2 n_3_2 100
Rh_2_3 n_2_3 n_2_4 100
Rv_2_3 n_2_3 n_3_3 100
Rh_2_4 n_2_4 n_2_5 100
Rv_2_4 n_2_4 n_3_4 100
Rh_2_5 n_2_5 n_2_6 100
Rv_2_5 n_2_5 n_3_5 100
Rh_2_6 n_2_6 n_2_7 100
Rv_2_6 n_2_6 n_3_6 100
Rh_2_7 n_2_7 n_2_8 100
Rv_2_7 n_2_7 n_3_7 100
Rh_2_8 n_2_8 n_2_9 100
Rv_2_8 n_2_8 n_3_8 100
Rv_2_9 n_2_9 n_3_9 100
Rh_3_0 n_3_0 n_3_1 100
Rv_3_0 n_3_0 n_4_0 100
Rh_3_1 n_3_1 n_3_2 100
Rv_3_1 n_3_1 n_4_1 100
Rh_3_2 n_3_2 n_3_3 100
Rv_3_2 n_3_2 n_4_2 100
Rh_3_3 n_3_3 n_3_4 100
Rv_3_3 n_3_3 n_4_3 100
Rh_3_4 n_3_4 n_3_5 100
Rv_3_4 n_3_4 n_4_4 100
Rh_3_5 n_3_5 n_3_6 100
Rv_3_5 n_3_5 n_4_5 100
Rh_3_6 n_3_6 n_3_7 100
Rv_3_6 n_3_6 n_4_6 100
Rh_3_7 n_3_7 n_3_8 100
Rv_3_7 n_3_7 n_4_7 100
Rh_3_8 n_3_8 n_3_9 100
Rv_3_8 n_3_8 n_4_8 100
Rv_3_9 n_3_9 n_4_9 100
Rh_4_0 n_4_0 n_4_1 100
Rv_4_0 n_4_0 n_5_0 100
Rh_4_1 n_4_1 n_4_2 100
Rv_4_1 n_4_1 n_5_1 100
Rh_4_2 n_4_2 n_4_3 100
Rv_4_2 n_4_2 n_5_2 100
Rh_4_3 n_4_3 n_4_4 100
Rv_4_3 n_4_3 n_5_3 100
Rh_4_4 n_4_4 n_4_5 100
Rv_4_4 n_4_4 n_5_4 100
Rh_4_5 n_4_5 n_4_6 100
Rv_4_5 n_4_5 n_5_5 100
Rh_4_6 n_4_6 n_4_7 100
Rv_4_6 n_4_6 n_5_6 100
Rh_4_7 n_4_7 n_4_8 100
Rv_4_7 n_4_7 n_5_7 100
Rh_4_8 n_4_8 n_4_9 100
Rv_4_8 n_4_8 n_5_8 100
Rv_4_9 n_4_9 n_5_9 100
Rh_5_0 n_5_0 n_5_1 100
Rv_5_0 n_5_0 n_6_0 100
Rh_5_1 n_5_1 n_5_2 100
Rv_5_1 n_5_1 n_6_1 100
Rh_5_2 n_5_2 n_5_3 100
Rv_5_2 n_5_2 n_6_2 100
Rh_5_3 n_5_3 n_5_4 100
Rv_5_3 n_5_3 n_6_3 100
Rh_5_4 n_5_4 n_5_5 100
Rv_5_4 n_5_4 n_6_4 100
Rh_5_5 n_5_5 n_5_6 100
Rv_5_5 n_5_5 n_6_5 100
Rh_5_6 n_5_6 n_5_7 100
Rv_5_6 n_5_6 n_6_6 100
Rh_5_7 n_5_7 n_5_8 100
Rv_5_7 n_5_7 n_6_7 100
Rh_5_8 n_5_8 n_5_9 100
Rv_5_8 n_5_8 n_6_8 100
Rv_5_9 n_5_9 n_6_9 100
Rh_6_0 n_6_0 n_6_1 100
Rv_6_0 n_6_0 n_7_0 100
Rh_6_1 n_6_1 n_6_2 100
Rv_6_1 n_6_1 n_7_1 100
Rh_6_2 n_6_2 n_6_3 100
Rv_6_2 n_6_2 n_7_2 100
Rh_6_3 n_6_3 n_6_4 100
Rv_6_3 n_6_3 n_7_3 100
Rh_6_4 n_6_4 n_6_5 100
Rv_6_4 n_6_4 n_7_4 100
Rh_6_5 n_6_5 n_6_6 100
Rv_6_5 n_6_5 n_7_5 100
Rh_6_6 n_6_6 n_6_7 100
Rv_6_6 n_6_6 n_7_6 100
Rh_6_7 n_6_7 n_6_8 100
Rv_6_7 n_6_7 n_7_7 100
Rh_6_8 n_6_8 n_6_9 100
Rv_6_8 n_6_8 n_7_8 100
Rv_6_9 n_6_9 n_7_9 100
Rh_7_0 n_7_0 n_7_1 100
Rv_7_0 n_7_0 n_8_0 100
Rh_7_1 n_7_1 n_7_2 100
Rv_7_1 n_7_1 n_8_1 100
Rh_7_2 n_7_2 n_7_3 100
Rv_7_2 n_7_2 n_8_2 100
Rh_7_3 n_7_3 n_7_4 100
Rv_7_3 n_7_3 n_8_3 100
Rh_7_4 n_7_4 n_7_5 100
Rv_7_4 n_7_4 n_8_4 100
Rh_7_5 n_7_5 n_7_6 100
Rv_7_5 n_7_5 n_8_5 100
Rh_7_6 n_7_6 n_7_7 100
Rv_7_6 n_7_6 n_8_6 100
Rh_7_7 n_7_7 n_7_8 100
Rv_7_7 n_7_7 n_8_7 100
Rh_7_8 n_7_8 n_7_9 100
Rv_7_8 n_7_8 n_8_8 100
Rv_7_9 n_7_9 n_8_9 100
Rh_8_0 n_8_0 n_8_1 100
Rv_8_0 n_8_0 n_9_0 100
Rh_8_1 n_8_1 n_8_2 100
Rv_8_1 n_8_1 n_9_1 100
Rh_8_2 n_8_2 n_8_3 100
Rv_8_2 n_8_2 n_9_2 100
Rh_8_3 n_8_3 n_8_4 100
Rv_8_3 n_8_3 n_9_3 100
Rh_8_4 n_8_4 n_8_5 100
Rv_8_4 n_8_4 n_9_4 100
Rh_8_5 n_8_5 n_8_6 100
Rv_8_5 n_8_5 n_9_5 100
Rh_8_6 n_8_6 n_8_7 100
Rv_8_6 n_8_6 n_9_6 100
Rh_8_7 n_8_7 n_8_8 100
Rv_8_7 n_8_7 n_9_7 100
Rh_8_8 n_8_8 n_8_9 100
Rv_8_8 n_8_8 n_9_8 100
Rv_8_9 n_8_9 n_9_9 100
Rh_9_0 n_9_0 n_9_1 100
Rh_9_1 n_9_1 n_9_2 100
Rh_9_2 n_9_2 n_9_3 100
Rh_9_3 n_9_3 n_9_4 100
Rh_9_4 n_9_4 n_9_5 100
Rh_9_5 n_9_5 n_9_6 100
Rh_9_6 n_9_6 n_9_7 100
Rh_9_7 n_9_7 n_9_8 100
Rh_9_8 n_9_8 n_9_9 100
Rload n_9_9 0 50
.op
.end
