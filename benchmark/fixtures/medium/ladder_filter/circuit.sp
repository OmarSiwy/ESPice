* 20-section LC ladder low-pass filter: mid-scale AC sweep.
Vin n0 0 DC 0 AC 1
Rs n0 in 50
L1 in n1 10u
C1 n1 0 10n
L2 n1 n2 10u
C2 n2 0 10n
L3 n2 n3 10u
C3 n3 0 10n
L4 n3 n4 10u
C4 n4 0 10n
L5 n4 n5 10u
C5 n5 0 10n
L6 n5 n6 10u
C6 n6 0 10n
L7 n6 n7 10u
C7 n7 0 10n
L8 n7 n8 10u
C8 n8 0 10n
L9 n8 n9 10u
C9 n9 0 10n
L10 n9 n10 10u
C10 n10 0 10n
L11 n10 n11 10u
C11 n11 0 10n
L12 n11 n12 10u
C12 n12 0 10n
L13 n12 n13 10u
C13 n13 0 10n
L14 n13 n14 10u
C14 n14 0 10n
L15 n14 n15 10u
C15 n15 0 10n
L16 n15 n16 10u
C16 n16 0 10n
L17 n16 n17 10u
C17 n17 0 10n
L18 n17 n18 10u
C18 n18 0 10n
L19 n18 n19 10u
C19 n19 0 10n
L20 n19 n20 10u
C20 n20 0 10n
Rl n20 0 50
.ac dec 20 1k 10meg
.end
