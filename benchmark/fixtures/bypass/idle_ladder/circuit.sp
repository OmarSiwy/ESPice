* Bypass fixture: pulse hits stage 1 of a 40-stage RC-diode ladder; the
* wave dies within a few stages, leaving the tail latent (bypass food).
Vin m0 0 DC 0 PULSE(0 1 1u 10n 10n 2u 1m)
R1 m0 m1 1k
C1 m1 0 1n
D1 m1 0 dm
R2 m1 m2 1k
C2 m2 0 1n
D2 m2 0 dm
R3 m2 m3 1k
C3 m3 0 1n
D3 m3 0 dm
R4 m3 m4 1k
C4 m4 0 1n
D4 m4 0 dm
R5 m4 m5 1k
C5 m5 0 1n
D5 m5 0 dm
R6 m5 m6 1k
C6 m6 0 1n
D6 m6 0 dm
R7 m6 m7 1k
C7 m7 0 1n
D7 m7 0 dm
R8 m7 m8 1k
C8 m8 0 1n
D8 m8 0 dm
R9 m8 m9 1k
C9 m9 0 1n
D9 m9 0 dm
R10 m9 m10 1k
C10 m10 0 1n
D10 m10 0 dm
R11 m10 m11 1k
C11 m11 0 1n
D11 m11 0 dm
R12 m11 m12 1k
C12 m12 0 1n
D12 m12 0 dm
R13 m12 m13 1k
C13 m13 0 1n
D13 m13 0 dm
R14 m13 m14 1k
C14 m14 0 1n
D14 m14 0 dm
R15 m14 m15 1k
C15 m15 0 1n
D15 m15 0 dm
R16 m15 m16 1k
C16 m16 0 1n
D16 m16 0 dm
R17 m16 m17 1k
C17 m17 0 1n
D17 m17 0 dm
R18 m17 m18 1k
C18 m18 0 1n
D18 m18 0 dm
R19 m18 m19 1k
C19 m19 0 1n
D19 m19 0 dm
R20 m19 m20 1k
C20 m20 0 1n
D20 m20 0 dm
R21 m20 m21 1k
C21 m21 0 1n
D21 m21 0 dm
R22 m21 m22 1k
C22 m22 0 1n
D22 m22 0 dm
R23 m22 m23 1k
C23 m23 0 1n
D23 m23 0 dm
R24 m23 m24 1k
C24 m24 0 1n
D24 m24 0 dm
R25 m24 m25 1k
C25 m25 0 1n
D25 m25 0 dm
R26 m25 m26 1k
C26 m26 0 1n
D26 m26 0 dm
R27 m26 m27 1k
C27 m27 0 1n
D27 m27 0 dm
R28 m27 m28 1k
C28 m28 0 1n
D28 m28 0 dm
R29 m28 m29 1k
C29 m29 0 1n
D29 m29 0 dm
R30 m29 m30 1k
C30 m30 0 1n
D30 m30 0 dm
R31 m30 m31 1k
C31 m31 0 1n
D31 m31 0 dm
R32 m31 m32 1k
C32 m32 0 1n
D32 m32 0 dm
R33 m32 m33 1k
C33 m33 0 1n
D33 m33 0 dm
R34 m33 m34 1k
C34 m34 0 1n
D34 m34 0 dm
R35 m34 m35 1k
C35 m35 0 1n
D35 m35 0 dm
R36 m35 m36 1k
C36 m36 0 1n
D36 m36 0 dm
R37 m36 m37 1k
C37 m37 0 1n
D37 m37 0 dm
R38 m37 m38 1k
C38 m38 0 1n
D38 m38 0 dm
R39 m38 m39 1k
C39 m39 0 1n
D39 m39 0 dm
R40 m39 m40 1k
C40 m40 0 1n
D40 m40 0 dm
.model dm D(is=1e-14)
.tran 0.5u 200u
.end
