* PZ fixture: two cascaded RC sections, two real poles.
Vin in 0 DC 0 AC 1
R1 in n1 1k
C1 n1 0 100n
R2 n1 out 10k
C2 out 0 10n
.pz in 0 out 0 vol pz
.end
