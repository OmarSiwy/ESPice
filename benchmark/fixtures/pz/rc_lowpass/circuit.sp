* PZ bench fixture: first-order RC low-pass pole extraction.
Vin in 0 DC 0 AC 1
R1 in out 1k
C1 out 0 1u
.pz out 0 in 0
.end
