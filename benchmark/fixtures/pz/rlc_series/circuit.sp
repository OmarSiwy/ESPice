* PZ fixture: series RLC, complex pole pair extraction.
Vin in 0 DC 0 AC 1
R1 in n1 100
L1 n1 out 1m
C1 out 0 100n
.pz in 0 out 0 vol pz
.end
