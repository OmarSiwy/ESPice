* Behavioral B-source implementing a squaring function I = k*V(in)^2.
Vin in 0 DC 2
B1 out 0 I={0.001*V(in)*V(in)}
R1 out 0 1k
.dc Vin 0 3 0.1
.end
