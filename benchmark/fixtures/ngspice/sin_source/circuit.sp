* SIN waveform with offset and damping into an RC low-pass.
Vin in 0 SIN(1 2 5k 0 0)
R1 in out 1k
C1 out 0 47n
.tran 2u 1m
.end
