* RC low-pass noise bandwidth: kT/C noise shaped by the pole.
Vin in 0 DC 0 AC 1
R1 in out 100k
C1 out 0 100p
.noise V(out) Vin dec 20 1 10meg
.end
