* Thermal noise floor of a single resistor seen at the output node.
Vin in 0 DC 0 AC 1
R1 in out 10k
R2 out 0 10k
.noise V(out) Vin dec 10 10 100k
.end
