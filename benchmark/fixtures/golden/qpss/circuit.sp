* Golden qpss: dispatch smoke; fixed unit-current driver limits accuracy coverage.
Vin in 0 DC 0
R1 in out 1k
C1 out 0 1u
.qpss 1k 1414.213562 1 1
.end
