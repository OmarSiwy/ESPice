* Golden tran: RC step.
Vin in 0 DC 0 PULSE(0 1 1u 10n 10n 50u 100u)
R1 in out 1k
C1 out 0 1n
.tran 0.1u 10u
.end
