* Golden pss: driven RC periodic state.
Vin in 0 DC 0 SIN(0 2 1k)
R1 in out 1k
C1 out 0 1u
.pss 1k 128
.end
