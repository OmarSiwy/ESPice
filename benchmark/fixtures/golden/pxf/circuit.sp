* Golden pxf: analysis dispatch and finite-output fixture.
Vin in 0 DC 0 AC 1 SIN(0 1 1k)
R1 in out 1k
C1 out 0 1u
.pxf 1k dec 2 10 100
.end
