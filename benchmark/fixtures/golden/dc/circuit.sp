* Golden dc: divider sweep.
Vin in 0 DC 0
R1 in out 1k
R2 out 0 3k
.dc Vin 0 5 0.5
.end
