* Golden stb: resistive VCVS feedback loop, T ≈ 100/11 ≈ 9.09 (flat).
Vin in 0 DC 0
R4 in sum 1k
E1 amp 0 sum 0 100
Vprb amp fb DC 0
R2 fb sum 10k
R3 fb 0 1k
.stb Vprb dec 5 1 100k
.end
