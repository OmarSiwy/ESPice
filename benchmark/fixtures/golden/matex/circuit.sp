* Golden matex: analysis dispatch and finite-output fixture.
Vin in 0 PULSE(0 1 0 1u 1u 100u 200u)
R1 in out 1k
C1 out 0 1n
.matex 1u 10u
.end
