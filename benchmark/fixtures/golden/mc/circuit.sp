* Golden mc: analysis dispatch and finite-output fixture.
Vin in 0 DC 10 AC 1
R1 in out 1k
R2 out 0 3k
.mc 4
.end
