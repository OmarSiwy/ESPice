* Golden sp: 50-ohm pi attenuator.
VP1 in 0 DC 0 AC 1 portnum 1 z0 50
R1 in 0 150
R2 in out 37.5
R3 out 0 150
VP2 out 0 DC 0 portnum 2 z0 50
.sp dec 5 1meg 100meg
.end
