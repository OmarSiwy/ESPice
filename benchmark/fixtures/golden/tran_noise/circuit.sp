* Golden tran_noise: analysis dispatch and finite-output fixture.
Vin in 0 DC 0 AC 1 SIN(0 1 1k)
R1 in out 1k
C1 out 0 1u
.trannoise 1u 10u
.end
