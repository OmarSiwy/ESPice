* Golden noise: divider thermal noise.
Vin in 0 DC 0 AC 1
R1 in out 1k
R2 out 0 3k
.noise v(out) Vin dec 5 10 100k
.end
