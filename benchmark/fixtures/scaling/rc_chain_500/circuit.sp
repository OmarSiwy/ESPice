* RC chain, 500 sections (500+ nodes): performance scaling transient.
Vin n0 0 DC 0 PULSE(0 1 0 1n 1n 500u 1m)
R1 n0 n1 1k
C1 n1 0 100p
R2 n1 n2 1k
C2 n2 0 100p
R3 n2 n3 1k
C3 n3 0 100p
R4 n3 n4 1k
C4 n4 0 100p
R5 n4 n5 1k
C5 n5 0 100p
R6 n5 n6 1k
C6 n6 0 100p
R7 n6 n7 1k
C7 n7 0 100p
R8 n7 n8 1k
C8 n8 0 100p
R9 n8 n9 1k
C9 n9 0 100p
R10 n9 n10 1k
C10 n10 0 100p
R11 n10 n11 1k
C11 n11 0 100p
R12 n11 n12 1k
C12 n12 0 100p
R13 n12 n13 1k
C13 n13 0 100p
R14 n13 n14 1k
C14 n14 0 100p
R15 n14 n15 1k
C15 n15 0 100p
R16 n15 n16 1k
C16 n16 0 100p
R17 n16 n17 1k
C17 n17 0 100p
R18 n17 n18 1k
C18 n18 0 100p
R19 n18 n19 1k
C19 n19 0 100p
R20 n19 n20 1k
C20 n20 0 100p
R21 n20 n21 1k
C21 n21 0 100p
R22 n21 n22 1k
C22 n22 0 100p
R23 n22 n23 1k
C23 n23 0 100p
R24 n23 n24 1k
C24 n24 0 100p
R25 n24 n25 1k
C25 n25 0 100p
R26 n25 n26 1k
C26 n26 0 100p
R27 n26 n27 1k
C27 n27 0 100p
R28 n27 n28 1k
C28 n28 0 100p
R29 n28 n29 1k
C29 n29 0 100p
R30 n29 n30 1k
C30 n30 0 100p
R31 n30 n31 1k
C31 n31 0 100p
R32 n31 n32 1k
C32 n32 0 100p
R33 n32 n33 1k
C33 n33 0 100p
R34 n33 n34 1k
C34 n34 0 100p
R35 n34 n35 1k
C35 n35 0 100p
R36 n35 n36 1k
C36 n36 0 100p
R37 n36 n37 1k
C37 n37 0 100p
R38 n37 n38 1k
C38 n38 0 100p
R39 n38 n39 1k
C39 n39 0 100p
R40 n39 n40 1k
C40 n40 0 100p
R41 n40 n41 1k
C41 n41 0 100p
R42 n41 n42 1k
C42 n42 0 100p
R43 n42 n43 1k
C43 n43 0 100p
R44 n43 n44 1k
C44 n44 0 100p
R45 n44 n45 1k
C45 n45 0 100p
R46 n45 n46 1k
C46 n46 0 100p
R47 n46 n47 1k
C47 n47 0 100p
R48 n47 n48 1k
C48 n48 0 100p
R49 n48 n49 1k
C49 n49 0 100p
R50 n49 n50 1k
C50 n50 0 100p
R51 n50 n51 1k
C51 n51 0 100p
R52 n51 n52 1k
C52 n52 0 100p
R53 n52 n53 1k
C53 n53 0 100p
R54 n53 n54 1k
C54 n54 0 100p
R55 n54 n55 1k
C55 n55 0 100p
R56 n55 n56 1k
C56 n56 0 100p
R57 n56 n57 1k
C57 n57 0 100p
R58 n57 n58 1k
C58 n58 0 100p
R59 n58 n59 1k
C59 n59 0 100p
R60 n59 n60 1k
C60 n60 0 100p
R61 n60 n61 1k
C61 n61 0 100p
R62 n61 n62 1k
C62 n62 0 100p
R63 n62 n63 1k
C63 n63 0 100p
R64 n63 n64 1k
C64 n64 0 100p
R65 n64 n65 1k
C65 n65 0 100p
R66 n65 n66 1k
C66 n66 0 100p
R67 n66 n67 1k
C67 n67 0 100p
R68 n67 n68 1k
C68 n68 0 100p
R69 n68 n69 1k
C69 n69 0 100p
R70 n69 n70 1k
C70 n70 0 100p
R71 n70 n71 1k
C71 n71 0 100p
R72 n71 n72 1k
C72 n72 0 100p
R73 n72 n73 1k
C73 n73 0 100p
R74 n73 n74 1k
C74 n74 0 100p
R75 n74 n75 1k
C75 n75 0 100p
R76 n75 n76 1k
C76 n76 0 100p
R77 n76 n77 1k
C77 n77 0 100p
R78 n77 n78 1k
C78 n78 0 100p
R79 n78 n79 1k
C79 n79 0 100p
R80 n79 n80 1k
C80 n80 0 100p
R81 n80 n81 1k
C81 n81 0 100p
R82 n81 n82 1k
C82 n82 0 100p
R83 n82 n83 1k
C83 n83 0 100p
R84 n83 n84 1k
C84 n84 0 100p
R85 n84 n85 1k
C85 n85 0 100p
R86 n85 n86 1k
C86 n86 0 100p
R87 n86 n87 1k
C87 n87 0 100p
R88 n87 n88 1k
C88 n88 0 100p
R89 n88 n89 1k
C89 n89 0 100p
R90 n89 n90 1k
C90 n90 0 100p
R91 n90 n91 1k
C91 n91 0 100p
R92 n91 n92 1k
C92 n92 0 100p
R93 n92 n93 1k
C93 n93 0 100p
R94 n93 n94 1k
C94 n94 0 100p
R95 n94 n95 1k
C95 n95 0 100p
R96 n95 n96 1k
C96 n96 0 100p
R97 n96 n97 1k
C97 n97 0 100p
R98 n97 n98 1k
C98 n98 0 100p
R99 n98 n99 1k
C99 n99 0 100p
R100 n99 n100 1k
C100 n100 0 100p
R101 n100 n101 1k
C101 n101 0 100p
R102 n101 n102 1k
C102 n102 0 100p
R103 n102 n103 1k
C103 n103 0 100p
R104 n103 n104 1k
C104 n104 0 100p
R105 n104 n105 1k
C105 n105 0 100p
R106 n105 n106 1k
C106 n106 0 100p
R107 n106 n107 1k
C107 n107 0 100p
R108 n107 n108 1k
C108 n108 0 100p
R109 n108 n109 1k
C109 n109 0 100p
R110 n109 n110 1k
C110 n110 0 100p
R111 n110 n111 1k
C111 n111 0 100p
R112 n111 n112 1k
C112 n112 0 100p
R113 n112 n113 1k
C113 n113 0 100p
R114 n113 n114 1k
C114 n114 0 100p
R115 n114 n115 1k
C115 n115 0 100p
R116 n115 n116 1k
C116 n116 0 100p
R117 n116 n117 1k
C117 n117 0 100p
R118 n117 n118 1k
C118 n118 0 100p
R119 n118 n119 1k
C119 n119 0 100p
R120 n119 n120 1k
C120 n120 0 100p
R121 n120 n121 1k
C121 n121 0 100p
R122 n121 n122 1k
C122 n122 0 100p
R123 n122 n123 1k
C123 n123 0 100p
R124 n123 n124 1k
C124 n124 0 100p
R125 n124 n125 1k
C125 n125 0 100p
R126 n125 n126 1k
C126 n126 0 100p
R127 n126 n127 1k
C127 n127 0 100p
R128 n127 n128 1k
C128 n128 0 100p
R129 n128 n129 1k
C129 n129 0 100p
R130 n129 n130 1k
C130 n130 0 100p
R131 n130 n131 1k
C131 n131 0 100p
R132 n131 n132 1k
C132 n132 0 100p
R133 n132 n133 1k
C133 n133 0 100p
R134 n133 n134 1k
C134 n134 0 100p
R135 n134 n135 1k
C135 n135 0 100p
R136 n135 n136 1k
C136 n136 0 100p
R137 n136 n137 1k
C137 n137 0 100p
R138 n137 n138 1k
C138 n138 0 100p
R139 n138 n139 1k
C139 n139 0 100p
R140 n139 n140 1k
C140 n140 0 100p
R141 n140 n141 1k
C141 n141 0 100p
R142 n141 n142 1k
C142 n142 0 100p
R143 n142 n143 1k
C143 n143 0 100p
R144 n143 n144 1k
C144 n144 0 100p
R145 n144 n145 1k
C145 n145 0 100p
R146 n145 n146 1k
C146 n146 0 100p
R147 n146 n147 1k
C147 n147 0 100p
R148 n147 n148 1k
C148 n148 0 100p
R149 n148 n149 1k
C149 n149 0 100p
R150 n149 n150 1k
C150 n150 0 100p
R151 n150 n151 1k
C151 n151 0 100p
R152 n151 n152 1k
C152 n152 0 100p
R153 n152 n153 1k
C153 n153 0 100p
R154 n153 n154 1k
C154 n154 0 100p
R155 n154 n155 1k
C155 n155 0 100p
R156 n155 n156 1k
C156 n156 0 100p
R157 n156 n157 1k
C157 n157 0 100p
R158 n157 n158 1k
C158 n158 0 100p
R159 n158 n159 1k
C159 n159 0 100p
R160 n159 n160 1k
C160 n160 0 100p
R161 n160 n161 1k
C161 n161 0 100p
R162 n161 n162 1k
C162 n162 0 100p
R163 n162 n163 1k
C163 n163 0 100p
R164 n163 n164 1k
C164 n164 0 100p
R165 n164 n165 1k
C165 n165 0 100p
R166 n165 n166 1k
C166 n166 0 100p
R167 n166 n167 1k
C167 n167 0 100p
R168 n167 n168 1k
C168 n168 0 100p
R169 n168 n169 1k
C169 n169 0 100p
R170 n169 n170 1k
C170 n170 0 100p
R171 n170 n171 1k
C171 n171 0 100p
R172 n171 n172 1k
C172 n172 0 100p
R173 n172 n173 1k
C173 n173 0 100p
R174 n173 n174 1k
C174 n174 0 100p
R175 n174 n175 1k
C175 n175 0 100p
R176 n175 n176 1k
C176 n176 0 100p
R177 n176 n177 1k
C177 n177 0 100p
R178 n177 n178 1k
C178 n178 0 100p
R179 n178 n179 1k
C179 n179 0 100p
R180 n179 n180 1k
C180 n180 0 100p
R181 n180 n181 1k
C181 n181 0 100p
R182 n181 n182 1k
C182 n182 0 100p
R183 n182 n183 1k
C183 n183 0 100p
R184 n183 n184 1k
C184 n184 0 100p
R185 n184 n185 1k
C185 n185 0 100p
R186 n185 n186 1k
C186 n186 0 100p
R187 n186 n187 1k
C187 n187 0 100p
R188 n187 n188 1k
C188 n188 0 100p
R189 n188 n189 1k
C189 n189 0 100p
R190 n189 n190 1k
C190 n190 0 100p
R191 n190 n191 1k
C191 n191 0 100p
R192 n191 n192 1k
C192 n192 0 100p
R193 n192 n193 1k
C193 n193 0 100p
R194 n193 n194 1k
C194 n194 0 100p
R195 n194 n195 1k
C195 n195 0 100p
R196 n195 n196 1k
C196 n196 0 100p
R197 n196 n197 1k
C197 n197 0 100p
R198 n197 n198 1k
C198 n198 0 100p
R199 n198 n199 1k
C199 n199 0 100p
R200 n199 n200 1k
C200 n200 0 100p
R201 n200 n201 1k
C201 n201 0 100p
R202 n201 n202 1k
C202 n202 0 100p
R203 n202 n203 1k
C203 n203 0 100p
R204 n203 n204 1k
C204 n204 0 100p
R205 n204 n205 1k
C205 n205 0 100p
R206 n205 n206 1k
C206 n206 0 100p
R207 n206 n207 1k
C207 n207 0 100p
R208 n207 n208 1k
C208 n208 0 100p
R209 n208 n209 1k
C209 n209 0 100p
R210 n209 n210 1k
C210 n210 0 100p
R211 n210 n211 1k
C211 n211 0 100p
R212 n211 n212 1k
C212 n212 0 100p
R213 n212 n213 1k
C213 n213 0 100p
R214 n213 n214 1k
C214 n214 0 100p
R215 n214 n215 1k
C215 n215 0 100p
R216 n215 n216 1k
C216 n216 0 100p
R217 n216 n217 1k
C217 n217 0 100p
R218 n217 n218 1k
C218 n218 0 100p
R219 n218 n219 1k
C219 n219 0 100p
R220 n219 n220 1k
C220 n220 0 100p
R221 n220 n221 1k
C221 n221 0 100p
R222 n221 n222 1k
C222 n222 0 100p
R223 n222 n223 1k
C223 n223 0 100p
R224 n223 n224 1k
C224 n224 0 100p
R225 n224 n225 1k
C225 n225 0 100p
R226 n225 n226 1k
C226 n226 0 100p
R227 n226 n227 1k
C227 n227 0 100p
R228 n227 n228 1k
C228 n228 0 100p
R229 n228 n229 1k
C229 n229 0 100p
R230 n229 n230 1k
C230 n230 0 100p
R231 n230 n231 1k
C231 n231 0 100p
R232 n231 n232 1k
C232 n232 0 100p
R233 n232 n233 1k
C233 n233 0 100p
R234 n233 n234 1k
C234 n234 0 100p
R235 n234 n235 1k
C235 n235 0 100p
R236 n235 n236 1k
C236 n236 0 100p
R237 n236 n237 1k
C237 n237 0 100p
R238 n237 n238 1k
C238 n238 0 100p
R239 n238 n239 1k
C239 n239 0 100p
R240 n239 n240 1k
C240 n240 0 100p
R241 n240 n241 1k
C241 n241 0 100p
R242 n241 n242 1k
C242 n242 0 100p
R243 n242 n243 1k
C243 n243 0 100p
R244 n243 n244 1k
C244 n244 0 100p
R245 n244 n245 1k
C245 n245 0 100p
R246 n245 n246 1k
C246 n246 0 100p
R247 n246 n247 1k
C247 n247 0 100p
R248 n247 n248 1k
C248 n248 0 100p
R249 n248 n249 1k
C249 n249 0 100p
R250 n249 n250 1k
C250 n250 0 100p
R251 n250 n251 1k
C251 n251 0 100p
R252 n251 n252 1k
C252 n252 0 100p
R253 n252 n253 1k
C253 n253 0 100p
R254 n253 n254 1k
C254 n254 0 100p
R255 n254 n255 1k
C255 n255 0 100p
R256 n255 n256 1k
C256 n256 0 100p
R257 n256 n257 1k
C257 n257 0 100p
R258 n257 n258 1k
C258 n258 0 100p
R259 n258 n259 1k
C259 n259 0 100p
R260 n259 n260 1k
C260 n260 0 100p
R261 n260 n261 1k
C261 n261 0 100p
R262 n261 n262 1k
C262 n262 0 100p
R263 n262 n263 1k
C263 n263 0 100p
R264 n263 n264 1k
C264 n264 0 100p
R265 n264 n265 1k
C265 n265 0 100p
R266 n265 n266 1k
C266 n266 0 100p
R267 n266 n267 1k
C267 n267 0 100p
R268 n267 n268 1k
C268 n268 0 100p
R269 n268 n269 1k
C269 n269 0 100p
R270 n269 n270 1k
C270 n270 0 100p
R271 n270 n271 1k
C271 n271 0 100p
R272 n271 n272 1k
C272 n272 0 100p
R273 n272 n273 1k
C273 n273 0 100p
R274 n273 n274 1k
C274 n274 0 100p
R275 n274 n275 1k
C275 n275 0 100p
R276 n275 n276 1k
C276 n276 0 100p
R277 n276 n277 1k
C277 n277 0 100p
R278 n277 n278 1k
C278 n278 0 100p
R279 n278 n279 1k
C279 n279 0 100p
R280 n279 n280 1k
C280 n280 0 100p
R281 n280 n281 1k
C281 n281 0 100p
R282 n281 n282 1k
C282 n282 0 100p
R283 n282 n283 1k
C283 n283 0 100p
R284 n283 n284 1k
C284 n284 0 100p
R285 n284 n285 1k
C285 n285 0 100p
R286 n285 n286 1k
C286 n286 0 100p
R287 n286 n287 1k
C287 n287 0 100p
R288 n287 n288 1k
C288 n288 0 100p
R289 n288 n289 1k
C289 n289 0 100p
R290 n289 n290 1k
C290 n290 0 100p
R291 n290 n291 1k
C291 n291 0 100p
R292 n291 n292 1k
C292 n292 0 100p
R293 n292 n293 1k
C293 n293 0 100p
R294 n293 n294 1k
C294 n294 0 100p
R295 n294 n295 1k
C295 n295 0 100p
R296 n295 n296 1k
C296 n296 0 100p
R297 n296 n297 1k
C297 n297 0 100p
R298 n297 n298 1k
C298 n298 0 100p
R299 n298 n299 1k
C299 n299 0 100p
R300 n299 n300 1k
C300 n300 0 100p
R301 n300 n301 1k
C301 n301 0 100p
R302 n301 n302 1k
C302 n302 0 100p
R303 n302 n303 1k
C303 n303 0 100p
R304 n303 n304 1k
C304 n304 0 100p
R305 n304 n305 1k
C305 n305 0 100p
R306 n305 n306 1k
C306 n306 0 100p
R307 n306 n307 1k
C307 n307 0 100p
R308 n307 n308 1k
C308 n308 0 100p
R309 n308 n309 1k
C309 n309 0 100p
R310 n309 n310 1k
C310 n310 0 100p
R311 n310 n311 1k
C311 n311 0 100p
R312 n311 n312 1k
C312 n312 0 100p
R313 n312 n313 1k
C313 n313 0 100p
R314 n313 n314 1k
C314 n314 0 100p
R315 n314 n315 1k
C315 n315 0 100p
R316 n315 n316 1k
C316 n316 0 100p
R317 n316 n317 1k
C317 n317 0 100p
R318 n317 n318 1k
C318 n318 0 100p
R319 n318 n319 1k
C319 n319 0 100p
R320 n319 n320 1k
C320 n320 0 100p
R321 n320 n321 1k
C321 n321 0 100p
R322 n321 n322 1k
C322 n322 0 100p
R323 n322 n323 1k
C323 n323 0 100p
R324 n323 n324 1k
C324 n324 0 100p
R325 n324 n325 1k
C325 n325 0 100p
R326 n325 n326 1k
C326 n326 0 100p
R327 n326 n327 1k
C327 n327 0 100p
R328 n327 n328 1k
C328 n328 0 100p
R329 n328 n329 1k
C329 n329 0 100p
R330 n329 n330 1k
C330 n330 0 100p
R331 n330 n331 1k
C331 n331 0 100p
R332 n331 n332 1k
C332 n332 0 100p
R333 n332 n333 1k
C333 n333 0 100p
R334 n333 n334 1k
C334 n334 0 100p
R335 n334 n335 1k
C335 n335 0 100p
R336 n335 n336 1k
C336 n336 0 100p
R337 n336 n337 1k
C337 n337 0 100p
R338 n337 n338 1k
C338 n338 0 100p
R339 n338 n339 1k
C339 n339 0 100p
R340 n339 n340 1k
C340 n340 0 100p
R341 n340 n341 1k
C341 n341 0 100p
R342 n341 n342 1k
C342 n342 0 100p
R343 n342 n343 1k
C343 n343 0 100p
R344 n343 n344 1k
C344 n344 0 100p
R345 n344 n345 1k
C345 n345 0 100p
R346 n345 n346 1k
C346 n346 0 100p
R347 n346 n347 1k
C347 n347 0 100p
R348 n347 n348 1k
C348 n348 0 100p
R349 n348 n349 1k
C349 n349 0 100p
R350 n349 n350 1k
C350 n350 0 100p
R351 n350 n351 1k
C351 n351 0 100p
R352 n351 n352 1k
C352 n352 0 100p
R353 n352 n353 1k
C353 n353 0 100p
R354 n353 n354 1k
C354 n354 0 100p
R355 n354 n355 1k
C355 n355 0 100p
R356 n355 n356 1k
C356 n356 0 100p
R357 n356 n357 1k
C357 n357 0 100p
R358 n357 n358 1k
C358 n358 0 100p
R359 n358 n359 1k
C359 n359 0 100p
R360 n359 n360 1k
C360 n360 0 100p
R361 n360 n361 1k
C361 n361 0 100p
R362 n361 n362 1k
C362 n362 0 100p
R363 n362 n363 1k
C363 n363 0 100p
R364 n363 n364 1k
C364 n364 0 100p
R365 n364 n365 1k
C365 n365 0 100p
R366 n365 n366 1k
C366 n366 0 100p
R367 n366 n367 1k
C367 n367 0 100p
R368 n367 n368 1k
C368 n368 0 100p
R369 n368 n369 1k
C369 n369 0 100p
R370 n369 n370 1k
C370 n370 0 100p
R371 n370 n371 1k
C371 n371 0 100p
R372 n371 n372 1k
C372 n372 0 100p
R373 n372 n373 1k
C373 n373 0 100p
R374 n373 n374 1k
C374 n374 0 100p
R375 n374 n375 1k
C375 n375 0 100p
R376 n375 n376 1k
C376 n376 0 100p
R377 n376 n377 1k
C377 n377 0 100p
R378 n377 n378 1k
C378 n378 0 100p
R379 n378 n379 1k
C379 n379 0 100p
R380 n379 n380 1k
C380 n380 0 100p
R381 n380 n381 1k
C381 n381 0 100p
R382 n381 n382 1k
C382 n382 0 100p
R383 n382 n383 1k
C383 n383 0 100p
R384 n383 n384 1k
C384 n384 0 100p
R385 n384 n385 1k
C385 n385 0 100p
R386 n385 n386 1k
C386 n386 0 100p
R387 n386 n387 1k
C387 n387 0 100p
R388 n387 n388 1k
C388 n388 0 100p
R389 n388 n389 1k
C389 n389 0 100p
R390 n389 n390 1k
C390 n390 0 100p
R391 n390 n391 1k
C391 n391 0 100p
R392 n391 n392 1k
C392 n392 0 100p
R393 n392 n393 1k
C393 n393 0 100p
R394 n393 n394 1k
C394 n394 0 100p
R395 n394 n395 1k
C395 n395 0 100p
R396 n395 n396 1k
C396 n396 0 100p
R397 n396 n397 1k
C397 n397 0 100p
R398 n397 n398 1k
C398 n398 0 100p
R399 n398 n399 1k
C399 n399 0 100p
R400 n399 n400 1k
C400 n400 0 100p
R401 n400 n401 1k
C401 n401 0 100p
R402 n401 n402 1k
C402 n402 0 100p
R403 n402 n403 1k
C403 n403 0 100p
R404 n403 n404 1k
C404 n404 0 100p
R405 n404 n405 1k
C405 n405 0 100p
R406 n405 n406 1k
C406 n406 0 100p
R407 n406 n407 1k
C407 n407 0 100p
R408 n407 n408 1k
C408 n408 0 100p
R409 n408 n409 1k
C409 n409 0 100p
R410 n409 n410 1k
C410 n410 0 100p
R411 n410 n411 1k
C411 n411 0 100p
R412 n411 n412 1k
C412 n412 0 100p
R413 n412 n413 1k
C413 n413 0 100p
R414 n413 n414 1k
C414 n414 0 100p
R415 n414 n415 1k
C415 n415 0 100p
R416 n415 n416 1k
C416 n416 0 100p
R417 n416 n417 1k
C417 n417 0 100p
R418 n417 n418 1k
C418 n418 0 100p
R419 n418 n419 1k
C419 n419 0 100p
R420 n419 n420 1k
C420 n420 0 100p
R421 n420 n421 1k
C421 n421 0 100p
R422 n421 n422 1k
C422 n422 0 100p
R423 n422 n423 1k
C423 n423 0 100p
R424 n423 n424 1k
C424 n424 0 100p
R425 n424 n425 1k
C425 n425 0 100p
R426 n425 n426 1k
C426 n426 0 100p
R427 n426 n427 1k
C427 n427 0 100p
R428 n427 n428 1k
C428 n428 0 100p
R429 n428 n429 1k
C429 n429 0 100p
R430 n429 n430 1k
C430 n430 0 100p
R431 n430 n431 1k
C431 n431 0 100p
R432 n431 n432 1k
C432 n432 0 100p
R433 n432 n433 1k
C433 n433 0 100p
R434 n433 n434 1k
C434 n434 0 100p
R435 n434 n435 1k
C435 n435 0 100p
R436 n435 n436 1k
C436 n436 0 100p
R437 n436 n437 1k
C437 n437 0 100p
R438 n437 n438 1k
C438 n438 0 100p
R439 n438 n439 1k
C439 n439 0 100p
R440 n439 n440 1k
C440 n440 0 100p
R441 n440 n441 1k
C441 n441 0 100p
R442 n441 n442 1k
C442 n442 0 100p
R443 n442 n443 1k
C443 n443 0 100p
R444 n443 n444 1k
C444 n444 0 100p
R445 n444 n445 1k
C445 n445 0 100p
R446 n445 n446 1k
C446 n446 0 100p
R447 n446 n447 1k
C447 n447 0 100p
R448 n447 n448 1k
C448 n448 0 100p
R449 n448 n449 1k
C449 n449 0 100p
R450 n449 n450 1k
C450 n450 0 100p
R451 n450 n451 1k
C451 n451 0 100p
R452 n451 n452 1k
C452 n452 0 100p
R453 n452 n453 1k
C453 n453 0 100p
R454 n453 n454 1k
C454 n454 0 100p
R455 n454 n455 1k
C455 n455 0 100p
R456 n455 n456 1k
C456 n456 0 100p
R457 n456 n457 1k
C457 n457 0 100p
R458 n457 n458 1k
C458 n458 0 100p
R459 n458 n459 1k
C459 n459 0 100p
R460 n459 n460 1k
C460 n460 0 100p
R461 n460 n461 1k
C461 n461 0 100p
R462 n461 n462 1k
C462 n462 0 100p
R463 n462 n463 1k
C463 n463 0 100p
R464 n463 n464 1k
C464 n464 0 100p
R465 n464 n465 1k
C465 n465 0 100p
R466 n465 n466 1k
C466 n466 0 100p
R467 n466 n467 1k
C467 n467 0 100p
R468 n467 n468 1k
C468 n468 0 100p
R469 n468 n469 1k
C469 n469 0 100p
R470 n469 n470 1k
C470 n470 0 100p
R471 n470 n471 1k
C471 n471 0 100p
R472 n471 n472 1k
C472 n472 0 100p
R473 n472 n473 1k
C473 n473 0 100p
R474 n473 n474 1k
C474 n474 0 100p
R475 n474 n475 1k
C475 n475 0 100p
R476 n475 n476 1k
C476 n476 0 100p
R477 n476 n477 1k
C477 n477 0 100p
R478 n477 n478 1k
C478 n478 0 100p
R479 n478 n479 1k
C479 n479 0 100p
R480 n479 n480 1k
C480 n480 0 100p
R481 n480 n481 1k
C481 n481 0 100p
R482 n481 n482 1k
C482 n482 0 100p
R483 n482 n483 1k
C483 n483 0 100p
R484 n483 n484 1k
C484 n484 0 100p
R485 n484 n485 1k
C485 n485 0 100p
R486 n485 n486 1k
C486 n486 0 100p
R487 n486 n487 1k
C487 n487 0 100p
R488 n487 n488 1k
C488 n488 0 100p
R489 n488 n489 1k
C489 n489 0 100p
R490 n489 n490 1k
C490 n490 0 100p
R491 n490 n491 1k
C491 n491 0 100p
R492 n491 n492 1k
C492 n492 0 100p
R493 n492 n493 1k
C493 n493 0 100p
R494 n493 n494 1k
C494 n494 0 100p
R495 n494 n495 1k
C495 n495 0 100p
R496 n495 n496 1k
C496 n496 0 100p
R497 n496 n497 1k
C497 n497 0 100p
R498 n497 n498 1k
C498 n498 0 100p
R499 n498 n499 1k
C499 n499 0 100p
R500 n499 n500 1k
C500 n500 0 100p
.tran 5u 1m
.end
