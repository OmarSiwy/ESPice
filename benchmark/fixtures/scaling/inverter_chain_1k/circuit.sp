* CMOS Inverter Chain: 1000 stages — stress test
.model nch NMOS(level=1 VTO=0.7 KP=110u GAMMA=0.4 LAMBDA=0.04 PHI=0.65)
.model pch PMOS(level=1 VTO=-0.7 KP=50u GAMMA=0.57 LAMBDA=0.05 PHI=0.65)
Vdd vdd 0 DC 1.8
Vin in 0 PULSE(0 1.8 0 0.1n 0.1n 5n 10n)
Mn1 s1 in 0 0 nch W=0.5u L=0.18u
Mp1 s1 in vdd vdd pch W=1u L=0.18u
Mn2 s2 s1 0 0 nch W=0.5u L=0.18u
Mp2 s2 s1 vdd vdd pch W=1u L=0.18u
Mn3 s3 s2 0 0 nch W=0.5u L=0.18u
Mp3 s3 s2 vdd vdd pch W=1u L=0.18u
Mn4 s4 s3 0 0 nch W=0.5u L=0.18u
Mp4 s4 s3 vdd vdd pch W=1u L=0.18u
Mn5 s5 s4 0 0 nch W=0.5u L=0.18u
Mp5 s5 s4 vdd vdd pch W=1u L=0.18u
Mn6 s6 s5 0 0 nch W=0.5u L=0.18u
Mp6 s6 s5 vdd vdd pch W=1u L=0.18u
Mn7 s7 s6 0 0 nch W=0.5u L=0.18u
Mp7 s7 s6 vdd vdd pch W=1u L=0.18u
Mn8 s8 s7 0 0 nch W=0.5u L=0.18u
Mp8 s8 s7 vdd vdd pch W=1u L=0.18u
Mn9 s9 s8 0 0 nch W=0.5u L=0.18u
Mp9 s9 s8 vdd vdd pch W=1u L=0.18u
Mn10 s10 s9 0 0 nch W=0.5u L=0.18u
Mp10 s10 s9 vdd vdd pch W=1u L=0.18u
Mn11 s11 s10 0 0 nch W=0.5u L=0.18u
Mp11 s11 s10 vdd vdd pch W=1u L=0.18u
Mn12 s12 s11 0 0 nch W=0.5u L=0.18u
Mp12 s12 s11 vdd vdd pch W=1u L=0.18u
Mn13 s13 s12 0 0 nch W=0.5u L=0.18u
Mp13 s13 s12 vdd vdd pch W=1u L=0.18u
Mn14 s14 s13 0 0 nch W=0.5u L=0.18u
Mp14 s14 s13 vdd vdd pch W=1u L=0.18u
Mn15 s15 s14 0 0 nch W=0.5u L=0.18u
Mp15 s15 s14 vdd vdd pch W=1u L=0.18u
Mn16 s16 s15 0 0 nch W=0.5u L=0.18u
Mp16 s16 s15 vdd vdd pch W=1u L=0.18u
Mn17 s17 s16 0 0 nch W=0.5u L=0.18u
Mp17 s17 s16 vdd vdd pch W=1u L=0.18u
Mn18 s18 s17 0 0 nch W=0.5u L=0.18u
Mp18 s18 s17 vdd vdd pch W=1u L=0.18u
Mn19 s19 s18 0 0 nch W=0.5u L=0.18u
Mp19 s19 s18 vdd vdd pch W=1u L=0.18u
Mn20 s20 s19 0 0 nch W=0.5u L=0.18u
Mp20 s20 s19 vdd vdd pch W=1u L=0.18u
Mn21 s21 s20 0 0 nch W=0.5u L=0.18u
Mp21 s21 s20 vdd vdd pch W=1u L=0.18u
Mn22 s22 s21 0 0 nch W=0.5u L=0.18u
Mp22 s22 s21 vdd vdd pch W=1u L=0.18u
Mn23 s23 s22 0 0 nch W=0.5u L=0.18u
Mp23 s23 s22 vdd vdd pch W=1u L=0.18u
Mn24 s24 s23 0 0 nch W=0.5u L=0.18u
Mp24 s24 s23 vdd vdd pch W=1u L=0.18u
Mn25 s25 s24 0 0 nch W=0.5u L=0.18u
Mp25 s25 s24 vdd vdd pch W=1u L=0.18u
Mn26 s26 s25 0 0 nch W=0.5u L=0.18u
Mp26 s26 s25 vdd vdd pch W=1u L=0.18u
Mn27 s27 s26 0 0 nch W=0.5u L=0.18u
Mp27 s27 s26 vdd vdd pch W=1u L=0.18u
Mn28 s28 s27 0 0 nch W=0.5u L=0.18u
Mp28 s28 s27 vdd vdd pch W=1u L=0.18u
Mn29 s29 s28 0 0 nch W=0.5u L=0.18u
Mp29 s29 s28 vdd vdd pch W=1u L=0.18u
Mn30 s30 s29 0 0 nch W=0.5u L=0.18u
Mp30 s30 s29 vdd vdd pch W=1u L=0.18u
Mn31 s31 s30 0 0 nch W=0.5u L=0.18u
Mp31 s31 s30 vdd vdd pch W=1u L=0.18u
Mn32 s32 s31 0 0 nch W=0.5u L=0.18u
Mp32 s32 s31 vdd vdd pch W=1u L=0.18u
Mn33 s33 s32 0 0 nch W=0.5u L=0.18u
Mp33 s33 s32 vdd vdd pch W=1u L=0.18u
Mn34 s34 s33 0 0 nch W=0.5u L=0.18u
Mp34 s34 s33 vdd vdd pch W=1u L=0.18u
Mn35 s35 s34 0 0 nch W=0.5u L=0.18u
Mp35 s35 s34 vdd vdd pch W=1u L=0.18u
Mn36 s36 s35 0 0 nch W=0.5u L=0.18u
Mp36 s36 s35 vdd vdd pch W=1u L=0.18u
Mn37 s37 s36 0 0 nch W=0.5u L=0.18u
Mp37 s37 s36 vdd vdd pch W=1u L=0.18u
Mn38 s38 s37 0 0 nch W=0.5u L=0.18u
Mp38 s38 s37 vdd vdd pch W=1u L=0.18u
Mn39 s39 s38 0 0 nch W=0.5u L=0.18u
Mp39 s39 s38 vdd vdd pch W=1u L=0.18u
Mn40 s40 s39 0 0 nch W=0.5u L=0.18u
Mp40 s40 s39 vdd vdd pch W=1u L=0.18u
Mn41 s41 s40 0 0 nch W=0.5u L=0.18u
Mp41 s41 s40 vdd vdd pch W=1u L=0.18u
Mn42 s42 s41 0 0 nch W=0.5u L=0.18u
Mp42 s42 s41 vdd vdd pch W=1u L=0.18u
Mn43 s43 s42 0 0 nch W=0.5u L=0.18u
Mp43 s43 s42 vdd vdd pch W=1u L=0.18u
Mn44 s44 s43 0 0 nch W=0.5u L=0.18u
Mp44 s44 s43 vdd vdd pch W=1u L=0.18u
Mn45 s45 s44 0 0 nch W=0.5u L=0.18u
Mp45 s45 s44 vdd vdd pch W=1u L=0.18u
Mn46 s46 s45 0 0 nch W=0.5u L=0.18u
Mp46 s46 s45 vdd vdd pch W=1u L=0.18u
Mn47 s47 s46 0 0 nch W=0.5u L=0.18u
Mp47 s47 s46 vdd vdd pch W=1u L=0.18u
Mn48 s48 s47 0 0 nch W=0.5u L=0.18u
Mp48 s48 s47 vdd vdd pch W=1u L=0.18u
Mn49 s49 s48 0 0 nch W=0.5u L=0.18u
Mp49 s49 s48 vdd vdd pch W=1u L=0.18u
Mn50 s50 s49 0 0 nch W=0.5u L=0.18u
Mp50 s50 s49 vdd vdd pch W=1u L=0.18u
Mn51 s51 s50 0 0 nch W=0.5u L=0.18u
Mp51 s51 s50 vdd vdd pch W=1u L=0.18u
Mn52 s52 s51 0 0 nch W=0.5u L=0.18u
Mp52 s52 s51 vdd vdd pch W=1u L=0.18u
Mn53 s53 s52 0 0 nch W=0.5u L=0.18u
Mp53 s53 s52 vdd vdd pch W=1u L=0.18u
Mn54 s54 s53 0 0 nch W=0.5u L=0.18u
Mp54 s54 s53 vdd vdd pch W=1u L=0.18u
Mn55 s55 s54 0 0 nch W=0.5u L=0.18u
Mp55 s55 s54 vdd vdd pch W=1u L=0.18u
Mn56 s56 s55 0 0 nch W=0.5u L=0.18u
Mp56 s56 s55 vdd vdd pch W=1u L=0.18u
Mn57 s57 s56 0 0 nch W=0.5u L=0.18u
Mp57 s57 s56 vdd vdd pch W=1u L=0.18u
Mn58 s58 s57 0 0 nch W=0.5u L=0.18u
Mp58 s58 s57 vdd vdd pch W=1u L=0.18u
Mn59 s59 s58 0 0 nch W=0.5u L=0.18u
Mp59 s59 s58 vdd vdd pch W=1u L=0.18u
Mn60 s60 s59 0 0 nch W=0.5u L=0.18u
Mp60 s60 s59 vdd vdd pch W=1u L=0.18u
Mn61 s61 s60 0 0 nch W=0.5u L=0.18u
Mp61 s61 s60 vdd vdd pch W=1u L=0.18u
Mn62 s62 s61 0 0 nch W=0.5u L=0.18u
Mp62 s62 s61 vdd vdd pch W=1u L=0.18u
Mn63 s63 s62 0 0 nch W=0.5u L=0.18u
Mp63 s63 s62 vdd vdd pch W=1u L=0.18u
Mn64 s64 s63 0 0 nch W=0.5u L=0.18u
Mp64 s64 s63 vdd vdd pch W=1u L=0.18u
Mn65 s65 s64 0 0 nch W=0.5u L=0.18u
Mp65 s65 s64 vdd vdd pch W=1u L=0.18u
Mn66 s66 s65 0 0 nch W=0.5u L=0.18u
Mp66 s66 s65 vdd vdd pch W=1u L=0.18u
Mn67 s67 s66 0 0 nch W=0.5u L=0.18u
Mp67 s67 s66 vdd vdd pch W=1u L=0.18u
Mn68 s68 s67 0 0 nch W=0.5u L=0.18u
Mp68 s68 s67 vdd vdd pch W=1u L=0.18u
Mn69 s69 s68 0 0 nch W=0.5u L=0.18u
Mp69 s69 s68 vdd vdd pch W=1u L=0.18u
Mn70 s70 s69 0 0 nch W=0.5u L=0.18u
Mp70 s70 s69 vdd vdd pch W=1u L=0.18u
Mn71 s71 s70 0 0 nch W=0.5u L=0.18u
Mp71 s71 s70 vdd vdd pch W=1u L=0.18u
Mn72 s72 s71 0 0 nch W=0.5u L=0.18u
Mp72 s72 s71 vdd vdd pch W=1u L=0.18u
Mn73 s73 s72 0 0 nch W=0.5u L=0.18u
Mp73 s73 s72 vdd vdd pch W=1u L=0.18u
Mn74 s74 s73 0 0 nch W=0.5u L=0.18u
Mp74 s74 s73 vdd vdd pch W=1u L=0.18u
Mn75 s75 s74 0 0 nch W=0.5u L=0.18u
Mp75 s75 s74 vdd vdd pch W=1u L=0.18u
Mn76 s76 s75 0 0 nch W=0.5u L=0.18u
Mp76 s76 s75 vdd vdd pch W=1u L=0.18u
Mn77 s77 s76 0 0 nch W=0.5u L=0.18u
Mp77 s77 s76 vdd vdd pch W=1u L=0.18u
Mn78 s78 s77 0 0 nch W=0.5u L=0.18u
Mp78 s78 s77 vdd vdd pch W=1u L=0.18u
Mn79 s79 s78 0 0 nch W=0.5u L=0.18u
Mp79 s79 s78 vdd vdd pch W=1u L=0.18u
Mn80 s80 s79 0 0 nch W=0.5u L=0.18u
Mp80 s80 s79 vdd vdd pch W=1u L=0.18u
Mn81 s81 s80 0 0 nch W=0.5u L=0.18u
Mp81 s81 s80 vdd vdd pch W=1u L=0.18u
Mn82 s82 s81 0 0 nch W=0.5u L=0.18u
Mp82 s82 s81 vdd vdd pch W=1u L=0.18u
Mn83 s83 s82 0 0 nch W=0.5u L=0.18u
Mp83 s83 s82 vdd vdd pch W=1u L=0.18u
Mn84 s84 s83 0 0 nch W=0.5u L=0.18u
Mp84 s84 s83 vdd vdd pch W=1u L=0.18u
Mn85 s85 s84 0 0 nch W=0.5u L=0.18u
Mp85 s85 s84 vdd vdd pch W=1u L=0.18u
Mn86 s86 s85 0 0 nch W=0.5u L=0.18u
Mp86 s86 s85 vdd vdd pch W=1u L=0.18u
Mn87 s87 s86 0 0 nch W=0.5u L=0.18u
Mp87 s87 s86 vdd vdd pch W=1u L=0.18u
Mn88 s88 s87 0 0 nch W=0.5u L=0.18u
Mp88 s88 s87 vdd vdd pch W=1u L=0.18u
Mn89 s89 s88 0 0 nch W=0.5u L=0.18u
Mp89 s89 s88 vdd vdd pch W=1u L=0.18u
Mn90 s90 s89 0 0 nch W=0.5u L=0.18u
Mp90 s90 s89 vdd vdd pch W=1u L=0.18u
Mn91 s91 s90 0 0 nch W=0.5u L=0.18u
Mp91 s91 s90 vdd vdd pch W=1u L=0.18u
Mn92 s92 s91 0 0 nch W=0.5u L=0.18u
Mp92 s92 s91 vdd vdd pch W=1u L=0.18u
Mn93 s93 s92 0 0 nch W=0.5u L=0.18u
Mp93 s93 s92 vdd vdd pch W=1u L=0.18u
Mn94 s94 s93 0 0 nch W=0.5u L=0.18u
Mp94 s94 s93 vdd vdd pch W=1u L=0.18u
Mn95 s95 s94 0 0 nch W=0.5u L=0.18u
Mp95 s95 s94 vdd vdd pch W=1u L=0.18u
Mn96 s96 s95 0 0 nch W=0.5u L=0.18u
Mp96 s96 s95 vdd vdd pch W=1u L=0.18u
Mn97 s97 s96 0 0 nch W=0.5u L=0.18u
Mp97 s97 s96 vdd vdd pch W=1u L=0.18u
Mn98 s98 s97 0 0 nch W=0.5u L=0.18u
Mp98 s98 s97 vdd vdd pch W=1u L=0.18u
Mn99 s99 s98 0 0 nch W=0.5u L=0.18u
Mp99 s99 s98 vdd vdd pch W=1u L=0.18u
Mn100 s100 s99 0 0 nch W=0.5u L=0.18u
Mp100 s100 s99 vdd vdd pch W=1u L=0.18u
Mn101 s101 s100 0 0 nch W=0.5u L=0.18u
Mp101 s101 s100 vdd vdd pch W=1u L=0.18u
Mn102 s102 s101 0 0 nch W=0.5u L=0.18u
Mp102 s102 s101 vdd vdd pch W=1u L=0.18u
Mn103 s103 s102 0 0 nch W=0.5u L=0.18u
Mp103 s103 s102 vdd vdd pch W=1u L=0.18u
Mn104 s104 s103 0 0 nch W=0.5u L=0.18u
Mp104 s104 s103 vdd vdd pch W=1u L=0.18u
Mn105 s105 s104 0 0 nch W=0.5u L=0.18u
Mp105 s105 s104 vdd vdd pch W=1u L=0.18u
Mn106 s106 s105 0 0 nch W=0.5u L=0.18u
Mp106 s106 s105 vdd vdd pch W=1u L=0.18u
Mn107 s107 s106 0 0 nch W=0.5u L=0.18u
Mp107 s107 s106 vdd vdd pch W=1u L=0.18u
Mn108 s108 s107 0 0 nch W=0.5u L=0.18u
Mp108 s108 s107 vdd vdd pch W=1u L=0.18u
Mn109 s109 s108 0 0 nch W=0.5u L=0.18u
Mp109 s109 s108 vdd vdd pch W=1u L=0.18u
Mn110 s110 s109 0 0 nch W=0.5u L=0.18u
Mp110 s110 s109 vdd vdd pch W=1u L=0.18u
Mn111 s111 s110 0 0 nch W=0.5u L=0.18u
Mp111 s111 s110 vdd vdd pch W=1u L=0.18u
Mn112 s112 s111 0 0 nch W=0.5u L=0.18u
Mp112 s112 s111 vdd vdd pch W=1u L=0.18u
Mn113 s113 s112 0 0 nch W=0.5u L=0.18u
Mp113 s113 s112 vdd vdd pch W=1u L=0.18u
Mn114 s114 s113 0 0 nch W=0.5u L=0.18u
Mp114 s114 s113 vdd vdd pch W=1u L=0.18u
Mn115 s115 s114 0 0 nch W=0.5u L=0.18u
Mp115 s115 s114 vdd vdd pch W=1u L=0.18u
Mn116 s116 s115 0 0 nch W=0.5u L=0.18u
Mp116 s116 s115 vdd vdd pch W=1u L=0.18u
Mn117 s117 s116 0 0 nch W=0.5u L=0.18u
Mp117 s117 s116 vdd vdd pch W=1u L=0.18u
Mn118 s118 s117 0 0 nch W=0.5u L=0.18u
Mp118 s118 s117 vdd vdd pch W=1u L=0.18u
Mn119 s119 s118 0 0 nch W=0.5u L=0.18u
Mp119 s119 s118 vdd vdd pch W=1u L=0.18u
Mn120 s120 s119 0 0 nch W=0.5u L=0.18u
Mp120 s120 s119 vdd vdd pch W=1u L=0.18u
Mn121 s121 s120 0 0 nch W=0.5u L=0.18u
Mp121 s121 s120 vdd vdd pch W=1u L=0.18u
Mn122 s122 s121 0 0 nch W=0.5u L=0.18u
Mp122 s122 s121 vdd vdd pch W=1u L=0.18u
Mn123 s123 s122 0 0 nch W=0.5u L=0.18u
Mp123 s123 s122 vdd vdd pch W=1u L=0.18u
Mn124 s124 s123 0 0 nch W=0.5u L=0.18u
Mp124 s124 s123 vdd vdd pch W=1u L=0.18u
Mn125 s125 s124 0 0 nch W=0.5u L=0.18u
Mp125 s125 s124 vdd vdd pch W=1u L=0.18u
Mn126 s126 s125 0 0 nch W=0.5u L=0.18u
Mp126 s126 s125 vdd vdd pch W=1u L=0.18u
Mn127 s127 s126 0 0 nch W=0.5u L=0.18u
Mp127 s127 s126 vdd vdd pch W=1u L=0.18u
Mn128 s128 s127 0 0 nch W=0.5u L=0.18u
Mp128 s128 s127 vdd vdd pch W=1u L=0.18u
Mn129 s129 s128 0 0 nch W=0.5u L=0.18u
Mp129 s129 s128 vdd vdd pch W=1u L=0.18u
Mn130 s130 s129 0 0 nch W=0.5u L=0.18u
Mp130 s130 s129 vdd vdd pch W=1u L=0.18u
Mn131 s131 s130 0 0 nch W=0.5u L=0.18u
Mp131 s131 s130 vdd vdd pch W=1u L=0.18u
Mn132 s132 s131 0 0 nch W=0.5u L=0.18u
Mp132 s132 s131 vdd vdd pch W=1u L=0.18u
Mn133 s133 s132 0 0 nch W=0.5u L=0.18u
Mp133 s133 s132 vdd vdd pch W=1u L=0.18u
Mn134 s134 s133 0 0 nch W=0.5u L=0.18u
Mp134 s134 s133 vdd vdd pch W=1u L=0.18u
Mn135 s135 s134 0 0 nch W=0.5u L=0.18u
Mp135 s135 s134 vdd vdd pch W=1u L=0.18u
Mn136 s136 s135 0 0 nch W=0.5u L=0.18u
Mp136 s136 s135 vdd vdd pch W=1u L=0.18u
Mn137 s137 s136 0 0 nch W=0.5u L=0.18u
Mp137 s137 s136 vdd vdd pch W=1u L=0.18u
Mn138 s138 s137 0 0 nch W=0.5u L=0.18u
Mp138 s138 s137 vdd vdd pch W=1u L=0.18u
Mn139 s139 s138 0 0 nch W=0.5u L=0.18u
Mp139 s139 s138 vdd vdd pch W=1u L=0.18u
Mn140 s140 s139 0 0 nch W=0.5u L=0.18u
Mp140 s140 s139 vdd vdd pch W=1u L=0.18u
Mn141 s141 s140 0 0 nch W=0.5u L=0.18u
Mp141 s141 s140 vdd vdd pch W=1u L=0.18u
Mn142 s142 s141 0 0 nch W=0.5u L=0.18u
Mp142 s142 s141 vdd vdd pch W=1u L=0.18u
Mn143 s143 s142 0 0 nch W=0.5u L=0.18u
Mp143 s143 s142 vdd vdd pch W=1u L=0.18u
Mn144 s144 s143 0 0 nch W=0.5u L=0.18u
Mp144 s144 s143 vdd vdd pch W=1u L=0.18u
Mn145 s145 s144 0 0 nch W=0.5u L=0.18u
Mp145 s145 s144 vdd vdd pch W=1u L=0.18u
Mn146 s146 s145 0 0 nch W=0.5u L=0.18u
Mp146 s146 s145 vdd vdd pch W=1u L=0.18u
Mn147 s147 s146 0 0 nch W=0.5u L=0.18u
Mp147 s147 s146 vdd vdd pch W=1u L=0.18u
Mn148 s148 s147 0 0 nch W=0.5u L=0.18u
Mp148 s148 s147 vdd vdd pch W=1u L=0.18u
Mn149 s149 s148 0 0 nch W=0.5u L=0.18u
Mp149 s149 s148 vdd vdd pch W=1u L=0.18u
Mn150 s150 s149 0 0 nch W=0.5u L=0.18u
Mp150 s150 s149 vdd vdd pch W=1u L=0.18u
Mn151 s151 s150 0 0 nch W=0.5u L=0.18u
Mp151 s151 s150 vdd vdd pch W=1u L=0.18u
Mn152 s152 s151 0 0 nch W=0.5u L=0.18u
Mp152 s152 s151 vdd vdd pch W=1u L=0.18u
Mn153 s153 s152 0 0 nch W=0.5u L=0.18u
Mp153 s153 s152 vdd vdd pch W=1u L=0.18u
Mn154 s154 s153 0 0 nch W=0.5u L=0.18u
Mp154 s154 s153 vdd vdd pch W=1u L=0.18u
Mn155 s155 s154 0 0 nch W=0.5u L=0.18u
Mp155 s155 s154 vdd vdd pch W=1u L=0.18u
Mn156 s156 s155 0 0 nch W=0.5u L=0.18u
Mp156 s156 s155 vdd vdd pch W=1u L=0.18u
Mn157 s157 s156 0 0 nch W=0.5u L=0.18u
Mp157 s157 s156 vdd vdd pch W=1u L=0.18u
Mn158 s158 s157 0 0 nch W=0.5u L=0.18u
Mp158 s158 s157 vdd vdd pch W=1u L=0.18u
Mn159 s159 s158 0 0 nch W=0.5u L=0.18u
Mp159 s159 s158 vdd vdd pch W=1u L=0.18u
Mn160 s160 s159 0 0 nch W=0.5u L=0.18u
Mp160 s160 s159 vdd vdd pch W=1u L=0.18u
Mn161 s161 s160 0 0 nch W=0.5u L=0.18u
Mp161 s161 s160 vdd vdd pch W=1u L=0.18u
Mn162 s162 s161 0 0 nch W=0.5u L=0.18u
Mp162 s162 s161 vdd vdd pch W=1u L=0.18u
Mn163 s163 s162 0 0 nch W=0.5u L=0.18u
Mp163 s163 s162 vdd vdd pch W=1u L=0.18u
Mn164 s164 s163 0 0 nch W=0.5u L=0.18u
Mp164 s164 s163 vdd vdd pch W=1u L=0.18u
Mn165 s165 s164 0 0 nch W=0.5u L=0.18u
Mp165 s165 s164 vdd vdd pch W=1u L=0.18u
Mn166 s166 s165 0 0 nch W=0.5u L=0.18u
Mp166 s166 s165 vdd vdd pch W=1u L=0.18u
Mn167 s167 s166 0 0 nch W=0.5u L=0.18u
Mp167 s167 s166 vdd vdd pch W=1u L=0.18u
Mn168 s168 s167 0 0 nch W=0.5u L=0.18u
Mp168 s168 s167 vdd vdd pch W=1u L=0.18u
Mn169 s169 s168 0 0 nch W=0.5u L=0.18u
Mp169 s169 s168 vdd vdd pch W=1u L=0.18u
Mn170 s170 s169 0 0 nch W=0.5u L=0.18u
Mp170 s170 s169 vdd vdd pch W=1u L=0.18u
Mn171 s171 s170 0 0 nch W=0.5u L=0.18u
Mp171 s171 s170 vdd vdd pch W=1u L=0.18u
Mn172 s172 s171 0 0 nch W=0.5u L=0.18u
Mp172 s172 s171 vdd vdd pch W=1u L=0.18u
Mn173 s173 s172 0 0 nch W=0.5u L=0.18u
Mp173 s173 s172 vdd vdd pch W=1u L=0.18u
Mn174 s174 s173 0 0 nch W=0.5u L=0.18u
Mp174 s174 s173 vdd vdd pch W=1u L=0.18u
Mn175 s175 s174 0 0 nch W=0.5u L=0.18u
Mp175 s175 s174 vdd vdd pch W=1u L=0.18u
Mn176 s176 s175 0 0 nch W=0.5u L=0.18u
Mp176 s176 s175 vdd vdd pch W=1u L=0.18u
Mn177 s177 s176 0 0 nch W=0.5u L=0.18u
Mp177 s177 s176 vdd vdd pch W=1u L=0.18u
Mn178 s178 s177 0 0 nch W=0.5u L=0.18u
Mp178 s178 s177 vdd vdd pch W=1u L=0.18u
Mn179 s179 s178 0 0 nch W=0.5u L=0.18u
Mp179 s179 s178 vdd vdd pch W=1u L=0.18u
Mn180 s180 s179 0 0 nch W=0.5u L=0.18u
Mp180 s180 s179 vdd vdd pch W=1u L=0.18u
Mn181 s181 s180 0 0 nch W=0.5u L=0.18u
Mp181 s181 s180 vdd vdd pch W=1u L=0.18u
Mn182 s182 s181 0 0 nch W=0.5u L=0.18u
Mp182 s182 s181 vdd vdd pch W=1u L=0.18u
Mn183 s183 s182 0 0 nch W=0.5u L=0.18u
Mp183 s183 s182 vdd vdd pch W=1u L=0.18u
Mn184 s184 s183 0 0 nch W=0.5u L=0.18u
Mp184 s184 s183 vdd vdd pch W=1u L=0.18u
Mn185 s185 s184 0 0 nch W=0.5u L=0.18u
Mp185 s185 s184 vdd vdd pch W=1u L=0.18u
Mn186 s186 s185 0 0 nch W=0.5u L=0.18u
Mp186 s186 s185 vdd vdd pch W=1u L=0.18u
Mn187 s187 s186 0 0 nch W=0.5u L=0.18u
Mp187 s187 s186 vdd vdd pch W=1u L=0.18u
Mn188 s188 s187 0 0 nch W=0.5u L=0.18u
Mp188 s188 s187 vdd vdd pch W=1u L=0.18u
Mn189 s189 s188 0 0 nch W=0.5u L=0.18u
Mp189 s189 s188 vdd vdd pch W=1u L=0.18u
Mn190 s190 s189 0 0 nch W=0.5u L=0.18u
Mp190 s190 s189 vdd vdd pch W=1u L=0.18u
Mn191 s191 s190 0 0 nch W=0.5u L=0.18u
Mp191 s191 s190 vdd vdd pch W=1u L=0.18u
Mn192 s192 s191 0 0 nch W=0.5u L=0.18u
Mp192 s192 s191 vdd vdd pch W=1u L=0.18u
Mn193 s193 s192 0 0 nch W=0.5u L=0.18u
Mp193 s193 s192 vdd vdd pch W=1u L=0.18u
Mn194 s194 s193 0 0 nch W=0.5u L=0.18u
Mp194 s194 s193 vdd vdd pch W=1u L=0.18u
Mn195 s195 s194 0 0 nch W=0.5u L=0.18u
Mp195 s195 s194 vdd vdd pch W=1u L=0.18u
Mn196 s196 s195 0 0 nch W=0.5u L=0.18u
Mp196 s196 s195 vdd vdd pch W=1u L=0.18u
Mn197 s197 s196 0 0 nch W=0.5u L=0.18u
Mp197 s197 s196 vdd vdd pch W=1u L=0.18u
Mn198 s198 s197 0 0 nch W=0.5u L=0.18u
Mp198 s198 s197 vdd vdd pch W=1u L=0.18u
Mn199 s199 s198 0 0 nch W=0.5u L=0.18u
Mp199 s199 s198 vdd vdd pch W=1u L=0.18u
Mn200 s200 s199 0 0 nch W=0.5u L=0.18u
Mp200 s200 s199 vdd vdd pch W=1u L=0.18u
Mn201 s201 s200 0 0 nch W=0.5u L=0.18u
Mp201 s201 s200 vdd vdd pch W=1u L=0.18u
Mn202 s202 s201 0 0 nch W=0.5u L=0.18u
Mp202 s202 s201 vdd vdd pch W=1u L=0.18u
Mn203 s203 s202 0 0 nch W=0.5u L=0.18u
Mp203 s203 s202 vdd vdd pch W=1u L=0.18u
Mn204 s204 s203 0 0 nch W=0.5u L=0.18u
Mp204 s204 s203 vdd vdd pch W=1u L=0.18u
Mn205 s205 s204 0 0 nch W=0.5u L=0.18u
Mp205 s205 s204 vdd vdd pch W=1u L=0.18u
Mn206 s206 s205 0 0 nch W=0.5u L=0.18u
Mp206 s206 s205 vdd vdd pch W=1u L=0.18u
Mn207 s207 s206 0 0 nch W=0.5u L=0.18u
Mp207 s207 s206 vdd vdd pch W=1u L=0.18u
Mn208 s208 s207 0 0 nch W=0.5u L=0.18u
Mp208 s208 s207 vdd vdd pch W=1u L=0.18u
Mn209 s209 s208 0 0 nch W=0.5u L=0.18u
Mp209 s209 s208 vdd vdd pch W=1u L=0.18u
Mn210 s210 s209 0 0 nch W=0.5u L=0.18u
Mp210 s210 s209 vdd vdd pch W=1u L=0.18u
Mn211 s211 s210 0 0 nch W=0.5u L=0.18u
Mp211 s211 s210 vdd vdd pch W=1u L=0.18u
Mn212 s212 s211 0 0 nch W=0.5u L=0.18u
Mp212 s212 s211 vdd vdd pch W=1u L=0.18u
Mn213 s213 s212 0 0 nch W=0.5u L=0.18u
Mp213 s213 s212 vdd vdd pch W=1u L=0.18u
Mn214 s214 s213 0 0 nch W=0.5u L=0.18u
Mp214 s214 s213 vdd vdd pch W=1u L=0.18u
Mn215 s215 s214 0 0 nch W=0.5u L=0.18u
Mp215 s215 s214 vdd vdd pch W=1u L=0.18u
Mn216 s216 s215 0 0 nch W=0.5u L=0.18u
Mp216 s216 s215 vdd vdd pch W=1u L=0.18u
Mn217 s217 s216 0 0 nch W=0.5u L=0.18u
Mp217 s217 s216 vdd vdd pch W=1u L=0.18u
Mn218 s218 s217 0 0 nch W=0.5u L=0.18u
Mp218 s218 s217 vdd vdd pch W=1u L=0.18u
Mn219 s219 s218 0 0 nch W=0.5u L=0.18u
Mp219 s219 s218 vdd vdd pch W=1u L=0.18u
Mn220 s220 s219 0 0 nch W=0.5u L=0.18u
Mp220 s220 s219 vdd vdd pch W=1u L=0.18u
Mn221 s221 s220 0 0 nch W=0.5u L=0.18u
Mp221 s221 s220 vdd vdd pch W=1u L=0.18u
Mn222 s222 s221 0 0 nch W=0.5u L=0.18u
Mp222 s222 s221 vdd vdd pch W=1u L=0.18u
Mn223 s223 s222 0 0 nch W=0.5u L=0.18u
Mp223 s223 s222 vdd vdd pch W=1u L=0.18u
Mn224 s224 s223 0 0 nch W=0.5u L=0.18u
Mp224 s224 s223 vdd vdd pch W=1u L=0.18u
Mn225 s225 s224 0 0 nch W=0.5u L=0.18u
Mp225 s225 s224 vdd vdd pch W=1u L=0.18u
Mn226 s226 s225 0 0 nch W=0.5u L=0.18u
Mp226 s226 s225 vdd vdd pch W=1u L=0.18u
Mn227 s227 s226 0 0 nch W=0.5u L=0.18u
Mp227 s227 s226 vdd vdd pch W=1u L=0.18u
Mn228 s228 s227 0 0 nch W=0.5u L=0.18u
Mp228 s228 s227 vdd vdd pch W=1u L=0.18u
Mn229 s229 s228 0 0 nch W=0.5u L=0.18u
Mp229 s229 s228 vdd vdd pch W=1u L=0.18u
Mn230 s230 s229 0 0 nch W=0.5u L=0.18u
Mp230 s230 s229 vdd vdd pch W=1u L=0.18u
Mn231 s231 s230 0 0 nch W=0.5u L=0.18u
Mp231 s231 s230 vdd vdd pch W=1u L=0.18u
Mn232 s232 s231 0 0 nch W=0.5u L=0.18u
Mp232 s232 s231 vdd vdd pch W=1u L=0.18u
Mn233 s233 s232 0 0 nch W=0.5u L=0.18u
Mp233 s233 s232 vdd vdd pch W=1u L=0.18u
Mn234 s234 s233 0 0 nch W=0.5u L=0.18u
Mp234 s234 s233 vdd vdd pch W=1u L=0.18u
Mn235 s235 s234 0 0 nch W=0.5u L=0.18u
Mp235 s235 s234 vdd vdd pch W=1u L=0.18u
Mn236 s236 s235 0 0 nch W=0.5u L=0.18u
Mp236 s236 s235 vdd vdd pch W=1u L=0.18u
Mn237 s237 s236 0 0 nch W=0.5u L=0.18u
Mp237 s237 s236 vdd vdd pch W=1u L=0.18u
Mn238 s238 s237 0 0 nch W=0.5u L=0.18u
Mp238 s238 s237 vdd vdd pch W=1u L=0.18u
Mn239 s239 s238 0 0 nch W=0.5u L=0.18u
Mp239 s239 s238 vdd vdd pch W=1u L=0.18u
Mn240 s240 s239 0 0 nch W=0.5u L=0.18u
Mp240 s240 s239 vdd vdd pch W=1u L=0.18u
Mn241 s241 s240 0 0 nch W=0.5u L=0.18u
Mp241 s241 s240 vdd vdd pch W=1u L=0.18u
Mn242 s242 s241 0 0 nch W=0.5u L=0.18u
Mp242 s242 s241 vdd vdd pch W=1u L=0.18u
Mn243 s243 s242 0 0 nch W=0.5u L=0.18u
Mp243 s243 s242 vdd vdd pch W=1u L=0.18u
Mn244 s244 s243 0 0 nch W=0.5u L=0.18u
Mp244 s244 s243 vdd vdd pch W=1u L=0.18u
Mn245 s245 s244 0 0 nch W=0.5u L=0.18u
Mp245 s245 s244 vdd vdd pch W=1u L=0.18u
Mn246 s246 s245 0 0 nch W=0.5u L=0.18u
Mp246 s246 s245 vdd vdd pch W=1u L=0.18u
Mn247 s247 s246 0 0 nch W=0.5u L=0.18u
Mp247 s247 s246 vdd vdd pch W=1u L=0.18u
Mn248 s248 s247 0 0 nch W=0.5u L=0.18u
Mp248 s248 s247 vdd vdd pch W=1u L=0.18u
Mn249 s249 s248 0 0 nch W=0.5u L=0.18u
Mp249 s249 s248 vdd vdd pch W=1u L=0.18u
Mn250 s250 s249 0 0 nch W=0.5u L=0.18u
Mp250 s250 s249 vdd vdd pch W=1u L=0.18u
Mn251 s251 s250 0 0 nch W=0.5u L=0.18u
Mp251 s251 s250 vdd vdd pch W=1u L=0.18u
Mn252 s252 s251 0 0 nch W=0.5u L=0.18u
Mp252 s252 s251 vdd vdd pch W=1u L=0.18u
Mn253 s253 s252 0 0 nch W=0.5u L=0.18u
Mp253 s253 s252 vdd vdd pch W=1u L=0.18u
Mn254 s254 s253 0 0 nch W=0.5u L=0.18u
Mp254 s254 s253 vdd vdd pch W=1u L=0.18u
Mn255 s255 s254 0 0 nch W=0.5u L=0.18u
Mp255 s255 s254 vdd vdd pch W=1u L=0.18u
Mn256 s256 s255 0 0 nch W=0.5u L=0.18u
Mp256 s256 s255 vdd vdd pch W=1u L=0.18u
Mn257 s257 s256 0 0 nch W=0.5u L=0.18u
Mp257 s257 s256 vdd vdd pch W=1u L=0.18u
Mn258 s258 s257 0 0 nch W=0.5u L=0.18u
Mp258 s258 s257 vdd vdd pch W=1u L=0.18u
Mn259 s259 s258 0 0 nch W=0.5u L=0.18u
Mp259 s259 s258 vdd vdd pch W=1u L=0.18u
Mn260 s260 s259 0 0 nch W=0.5u L=0.18u
Mp260 s260 s259 vdd vdd pch W=1u L=0.18u
Mn261 s261 s260 0 0 nch W=0.5u L=0.18u
Mp261 s261 s260 vdd vdd pch W=1u L=0.18u
Mn262 s262 s261 0 0 nch W=0.5u L=0.18u
Mp262 s262 s261 vdd vdd pch W=1u L=0.18u
Mn263 s263 s262 0 0 nch W=0.5u L=0.18u
Mp263 s263 s262 vdd vdd pch W=1u L=0.18u
Mn264 s264 s263 0 0 nch W=0.5u L=0.18u
Mp264 s264 s263 vdd vdd pch W=1u L=0.18u
Mn265 s265 s264 0 0 nch W=0.5u L=0.18u
Mp265 s265 s264 vdd vdd pch W=1u L=0.18u
Mn266 s266 s265 0 0 nch W=0.5u L=0.18u
Mp266 s266 s265 vdd vdd pch W=1u L=0.18u
Mn267 s267 s266 0 0 nch W=0.5u L=0.18u
Mp267 s267 s266 vdd vdd pch W=1u L=0.18u
Mn268 s268 s267 0 0 nch W=0.5u L=0.18u
Mp268 s268 s267 vdd vdd pch W=1u L=0.18u
Mn269 s269 s268 0 0 nch W=0.5u L=0.18u
Mp269 s269 s268 vdd vdd pch W=1u L=0.18u
Mn270 s270 s269 0 0 nch W=0.5u L=0.18u
Mp270 s270 s269 vdd vdd pch W=1u L=0.18u
Mn271 s271 s270 0 0 nch W=0.5u L=0.18u
Mp271 s271 s270 vdd vdd pch W=1u L=0.18u
Mn272 s272 s271 0 0 nch W=0.5u L=0.18u
Mp272 s272 s271 vdd vdd pch W=1u L=0.18u
Mn273 s273 s272 0 0 nch W=0.5u L=0.18u
Mp273 s273 s272 vdd vdd pch W=1u L=0.18u
Mn274 s274 s273 0 0 nch W=0.5u L=0.18u
Mp274 s274 s273 vdd vdd pch W=1u L=0.18u
Mn275 s275 s274 0 0 nch W=0.5u L=0.18u
Mp275 s275 s274 vdd vdd pch W=1u L=0.18u
Mn276 s276 s275 0 0 nch W=0.5u L=0.18u
Mp276 s276 s275 vdd vdd pch W=1u L=0.18u
Mn277 s277 s276 0 0 nch W=0.5u L=0.18u
Mp277 s277 s276 vdd vdd pch W=1u L=0.18u
Mn278 s278 s277 0 0 nch W=0.5u L=0.18u
Mp278 s278 s277 vdd vdd pch W=1u L=0.18u
Mn279 s279 s278 0 0 nch W=0.5u L=0.18u
Mp279 s279 s278 vdd vdd pch W=1u L=0.18u
Mn280 s280 s279 0 0 nch W=0.5u L=0.18u
Mp280 s280 s279 vdd vdd pch W=1u L=0.18u
Mn281 s281 s280 0 0 nch W=0.5u L=0.18u
Mp281 s281 s280 vdd vdd pch W=1u L=0.18u
Mn282 s282 s281 0 0 nch W=0.5u L=0.18u
Mp282 s282 s281 vdd vdd pch W=1u L=0.18u
Mn283 s283 s282 0 0 nch W=0.5u L=0.18u
Mp283 s283 s282 vdd vdd pch W=1u L=0.18u
Mn284 s284 s283 0 0 nch W=0.5u L=0.18u
Mp284 s284 s283 vdd vdd pch W=1u L=0.18u
Mn285 s285 s284 0 0 nch W=0.5u L=0.18u
Mp285 s285 s284 vdd vdd pch W=1u L=0.18u
Mn286 s286 s285 0 0 nch W=0.5u L=0.18u
Mp286 s286 s285 vdd vdd pch W=1u L=0.18u
Mn287 s287 s286 0 0 nch W=0.5u L=0.18u
Mp287 s287 s286 vdd vdd pch W=1u L=0.18u
Mn288 s288 s287 0 0 nch W=0.5u L=0.18u
Mp288 s288 s287 vdd vdd pch W=1u L=0.18u
Mn289 s289 s288 0 0 nch W=0.5u L=0.18u
Mp289 s289 s288 vdd vdd pch W=1u L=0.18u
Mn290 s290 s289 0 0 nch W=0.5u L=0.18u
Mp290 s290 s289 vdd vdd pch W=1u L=0.18u
Mn291 s291 s290 0 0 nch W=0.5u L=0.18u
Mp291 s291 s290 vdd vdd pch W=1u L=0.18u
Mn292 s292 s291 0 0 nch W=0.5u L=0.18u
Mp292 s292 s291 vdd vdd pch W=1u L=0.18u
Mn293 s293 s292 0 0 nch W=0.5u L=0.18u
Mp293 s293 s292 vdd vdd pch W=1u L=0.18u
Mn294 s294 s293 0 0 nch W=0.5u L=0.18u
Mp294 s294 s293 vdd vdd pch W=1u L=0.18u
Mn295 s295 s294 0 0 nch W=0.5u L=0.18u
Mp295 s295 s294 vdd vdd pch W=1u L=0.18u
Mn296 s296 s295 0 0 nch W=0.5u L=0.18u
Mp296 s296 s295 vdd vdd pch W=1u L=0.18u
Mn297 s297 s296 0 0 nch W=0.5u L=0.18u
Mp297 s297 s296 vdd vdd pch W=1u L=0.18u
Mn298 s298 s297 0 0 nch W=0.5u L=0.18u
Mp298 s298 s297 vdd vdd pch W=1u L=0.18u
Mn299 s299 s298 0 0 nch W=0.5u L=0.18u
Mp299 s299 s298 vdd vdd pch W=1u L=0.18u
Mn300 s300 s299 0 0 nch W=0.5u L=0.18u
Mp300 s300 s299 vdd vdd pch W=1u L=0.18u
Mn301 s301 s300 0 0 nch W=0.5u L=0.18u
Mp301 s301 s300 vdd vdd pch W=1u L=0.18u
Mn302 s302 s301 0 0 nch W=0.5u L=0.18u
Mp302 s302 s301 vdd vdd pch W=1u L=0.18u
Mn303 s303 s302 0 0 nch W=0.5u L=0.18u
Mp303 s303 s302 vdd vdd pch W=1u L=0.18u
Mn304 s304 s303 0 0 nch W=0.5u L=0.18u
Mp304 s304 s303 vdd vdd pch W=1u L=0.18u
Mn305 s305 s304 0 0 nch W=0.5u L=0.18u
Mp305 s305 s304 vdd vdd pch W=1u L=0.18u
Mn306 s306 s305 0 0 nch W=0.5u L=0.18u
Mp306 s306 s305 vdd vdd pch W=1u L=0.18u
Mn307 s307 s306 0 0 nch W=0.5u L=0.18u
Mp307 s307 s306 vdd vdd pch W=1u L=0.18u
Mn308 s308 s307 0 0 nch W=0.5u L=0.18u
Mp308 s308 s307 vdd vdd pch W=1u L=0.18u
Mn309 s309 s308 0 0 nch W=0.5u L=0.18u
Mp309 s309 s308 vdd vdd pch W=1u L=0.18u
Mn310 s310 s309 0 0 nch W=0.5u L=0.18u
Mp310 s310 s309 vdd vdd pch W=1u L=0.18u
Mn311 s311 s310 0 0 nch W=0.5u L=0.18u
Mp311 s311 s310 vdd vdd pch W=1u L=0.18u
Mn312 s312 s311 0 0 nch W=0.5u L=0.18u
Mp312 s312 s311 vdd vdd pch W=1u L=0.18u
Mn313 s313 s312 0 0 nch W=0.5u L=0.18u
Mp313 s313 s312 vdd vdd pch W=1u L=0.18u
Mn314 s314 s313 0 0 nch W=0.5u L=0.18u
Mp314 s314 s313 vdd vdd pch W=1u L=0.18u
Mn315 s315 s314 0 0 nch W=0.5u L=0.18u
Mp315 s315 s314 vdd vdd pch W=1u L=0.18u
Mn316 s316 s315 0 0 nch W=0.5u L=0.18u
Mp316 s316 s315 vdd vdd pch W=1u L=0.18u
Mn317 s317 s316 0 0 nch W=0.5u L=0.18u
Mp317 s317 s316 vdd vdd pch W=1u L=0.18u
Mn318 s318 s317 0 0 nch W=0.5u L=0.18u
Mp318 s318 s317 vdd vdd pch W=1u L=0.18u
Mn319 s319 s318 0 0 nch W=0.5u L=0.18u
Mp319 s319 s318 vdd vdd pch W=1u L=0.18u
Mn320 s320 s319 0 0 nch W=0.5u L=0.18u
Mp320 s320 s319 vdd vdd pch W=1u L=0.18u
Mn321 s321 s320 0 0 nch W=0.5u L=0.18u
Mp321 s321 s320 vdd vdd pch W=1u L=0.18u
Mn322 s322 s321 0 0 nch W=0.5u L=0.18u
Mp322 s322 s321 vdd vdd pch W=1u L=0.18u
Mn323 s323 s322 0 0 nch W=0.5u L=0.18u
Mp323 s323 s322 vdd vdd pch W=1u L=0.18u
Mn324 s324 s323 0 0 nch W=0.5u L=0.18u
Mp324 s324 s323 vdd vdd pch W=1u L=0.18u
Mn325 s325 s324 0 0 nch W=0.5u L=0.18u
Mp325 s325 s324 vdd vdd pch W=1u L=0.18u
Mn326 s326 s325 0 0 nch W=0.5u L=0.18u
Mp326 s326 s325 vdd vdd pch W=1u L=0.18u
Mn327 s327 s326 0 0 nch W=0.5u L=0.18u
Mp327 s327 s326 vdd vdd pch W=1u L=0.18u
Mn328 s328 s327 0 0 nch W=0.5u L=0.18u
Mp328 s328 s327 vdd vdd pch W=1u L=0.18u
Mn329 s329 s328 0 0 nch W=0.5u L=0.18u
Mp329 s329 s328 vdd vdd pch W=1u L=0.18u
Mn330 s330 s329 0 0 nch W=0.5u L=0.18u
Mp330 s330 s329 vdd vdd pch W=1u L=0.18u
Mn331 s331 s330 0 0 nch W=0.5u L=0.18u
Mp331 s331 s330 vdd vdd pch W=1u L=0.18u
Mn332 s332 s331 0 0 nch W=0.5u L=0.18u
Mp332 s332 s331 vdd vdd pch W=1u L=0.18u
Mn333 s333 s332 0 0 nch W=0.5u L=0.18u
Mp333 s333 s332 vdd vdd pch W=1u L=0.18u
Mn334 s334 s333 0 0 nch W=0.5u L=0.18u
Mp334 s334 s333 vdd vdd pch W=1u L=0.18u
Mn335 s335 s334 0 0 nch W=0.5u L=0.18u
Mp335 s335 s334 vdd vdd pch W=1u L=0.18u
Mn336 s336 s335 0 0 nch W=0.5u L=0.18u
Mp336 s336 s335 vdd vdd pch W=1u L=0.18u
Mn337 s337 s336 0 0 nch W=0.5u L=0.18u
Mp337 s337 s336 vdd vdd pch W=1u L=0.18u
Mn338 s338 s337 0 0 nch W=0.5u L=0.18u
Mp338 s338 s337 vdd vdd pch W=1u L=0.18u
Mn339 s339 s338 0 0 nch W=0.5u L=0.18u
Mp339 s339 s338 vdd vdd pch W=1u L=0.18u
Mn340 s340 s339 0 0 nch W=0.5u L=0.18u
Mp340 s340 s339 vdd vdd pch W=1u L=0.18u
Mn341 s341 s340 0 0 nch W=0.5u L=0.18u
Mp341 s341 s340 vdd vdd pch W=1u L=0.18u
Mn342 s342 s341 0 0 nch W=0.5u L=0.18u
Mp342 s342 s341 vdd vdd pch W=1u L=0.18u
Mn343 s343 s342 0 0 nch W=0.5u L=0.18u
Mp343 s343 s342 vdd vdd pch W=1u L=0.18u
Mn344 s344 s343 0 0 nch W=0.5u L=0.18u
Mp344 s344 s343 vdd vdd pch W=1u L=0.18u
Mn345 s345 s344 0 0 nch W=0.5u L=0.18u
Mp345 s345 s344 vdd vdd pch W=1u L=0.18u
Mn346 s346 s345 0 0 nch W=0.5u L=0.18u
Mp346 s346 s345 vdd vdd pch W=1u L=0.18u
Mn347 s347 s346 0 0 nch W=0.5u L=0.18u
Mp347 s347 s346 vdd vdd pch W=1u L=0.18u
Mn348 s348 s347 0 0 nch W=0.5u L=0.18u
Mp348 s348 s347 vdd vdd pch W=1u L=0.18u
Mn349 s349 s348 0 0 nch W=0.5u L=0.18u
Mp349 s349 s348 vdd vdd pch W=1u L=0.18u
Mn350 s350 s349 0 0 nch W=0.5u L=0.18u
Mp350 s350 s349 vdd vdd pch W=1u L=0.18u
Mn351 s351 s350 0 0 nch W=0.5u L=0.18u
Mp351 s351 s350 vdd vdd pch W=1u L=0.18u
Mn352 s352 s351 0 0 nch W=0.5u L=0.18u
Mp352 s352 s351 vdd vdd pch W=1u L=0.18u
Mn353 s353 s352 0 0 nch W=0.5u L=0.18u
Mp353 s353 s352 vdd vdd pch W=1u L=0.18u
Mn354 s354 s353 0 0 nch W=0.5u L=0.18u
Mp354 s354 s353 vdd vdd pch W=1u L=0.18u
Mn355 s355 s354 0 0 nch W=0.5u L=0.18u
Mp355 s355 s354 vdd vdd pch W=1u L=0.18u
Mn356 s356 s355 0 0 nch W=0.5u L=0.18u
Mp356 s356 s355 vdd vdd pch W=1u L=0.18u
Mn357 s357 s356 0 0 nch W=0.5u L=0.18u
Mp357 s357 s356 vdd vdd pch W=1u L=0.18u
Mn358 s358 s357 0 0 nch W=0.5u L=0.18u
Mp358 s358 s357 vdd vdd pch W=1u L=0.18u
Mn359 s359 s358 0 0 nch W=0.5u L=0.18u
Mp359 s359 s358 vdd vdd pch W=1u L=0.18u
Mn360 s360 s359 0 0 nch W=0.5u L=0.18u
Mp360 s360 s359 vdd vdd pch W=1u L=0.18u
Mn361 s361 s360 0 0 nch W=0.5u L=0.18u
Mp361 s361 s360 vdd vdd pch W=1u L=0.18u
Mn362 s362 s361 0 0 nch W=0.5u L=0.18u
Mp362 s362 s361 vdd vdd pch W=1u L=0.18u
Mn363 s363 s362 0 0 nch W=0.5u L=0.18u
Mp363 s363 s362 vdd vdd pch W=1u L=0.18u
Mn364 s364 s363 0 0 nch W=0.5u L=0.18u
Mp364 s364 s363 vdd vdd pch W=1u L=0.18u
Mn365 s365 s364 0 0 nch W=0.5u L=0.18u
Mp365 s365 s364 vdd vdd pch W=1u L=0.18u
Mn366 s366 s365 0 0 nch W=0.5u L=0.18u
Mp366 s366 s365 vdd vdd pch W=1u L=0.18u
Mn367 s367 s366 0 0 nch W=0.5u L=0.18u
Mp367 s367 s366 vdd vdd pch W=1u L=0.18u
Mn368 s368 s367 0 0 nch W=0.5u L=0.18u
Mp368 s368 s367 vdd vdd pch W=1u L=0.18u
Mn369 s369 s368 0 0 nch W=0.5u L=0.18u
Mp369 s369 s368 vdd vdd pch W=1u L=0.18u
Mn370 s370 s369 0 0 nch W=0.5u L=0.18u
Mp370 s370 s369 vdd vdd pch W=1u L=0.18u
Mn371 s371 s370 0 0 nch W=0.5u L=0.18u
Mp371 s371 s370 vdd vdd pch W=1u L=0.18u
Mn372 s372 s371 0 0 nch W=0.5u L=0.18u
Mp372 s372 s371 vdd vdd pch W=1u L=0.18u
Mn373 s373 s372 0 0 nch W=0.5u L=0.18u
Mp373 s373 s372 vdd vdd pch W=1u L=0.18u
Mn374 s374 s373 0 0 nch W=0.5u L=0.18u
Mp374 s374 s373 vdd vdd pch W=1u L=0.18u
Mn375 s375 s374 0 0 nch W=0.5u L=0.18u
Mp375 s375 s374 vdd vdd pch W=1u L=0.18u
Mn376 s376 s375 0 0 nch W=0.5u L=0.18u
Mp376 s376 s375 vdd vdd pch W=1u L=0.18u
Mn377 s377 s376 0 0 nch W=0.5u L=0.18u
Mp377 s377 s376 vdd vdd pch W=1u L=0.18u
Mn378 s378 s377 0 0 nch W=0.5u L=0.18u
Mp378 s378 s377 vdd vdd pch W=1u L=0.18u
Mn379 s379 s378 0 0 nch W=0.5u L=0.18u
Mp379 s379 s378 vdd vdd pch W=1u L=0.18u
Mn380 s380 s379 0 0 nch W=0.5u L=0.18u
Mp380 s380 s379 vdd vdd pch W=1u L=0.18u
Mn381 s381 s380 0 0 nch W=0.5u L=0.18u
Mp381 s381 s380 vdd vdd pch W=1u L=0.18u
Mn382 s382 s381 0 0 nch W=0.5u L=0.18u
Mp382 s382 s381 vdd vdd pch W=1u L=0.18u
Mn383 s383 s382 0 0 nch W=0.5u L=0.18u
Mp383 s383 s382 vdd vdd pch W=1u L=0.18u
Mn384 s384 s383 0 0 nch W=0.5u L=0.18u
Mp384 s384 s383 vdd vdd pch W=1u L=0.18u
Mn385 s385 s384 0 0 nch W=0.5u L=0.18u
Mp385 s385 s384 vdd vdd pch W=1u L=0.18u
Mn386 s386 s385 0 0 nch W=0.5u L=0.18u
Mp386 s386 s385 vdd vdd pch W=1u L=0.18u
Mn387 s387 s386 0 0 nch W=0.5u L=0.18u
Mp387 s387 s386 vdd vdd pch W=1u L=0.18u
Mn388 s388 s387 0 0 nch W=0.5u L=0.18u
Mp388 s388 s387 vdd vdd pch W=1u L=0.18u
Mn389 s389 s388 0 0 nch W=0.5u L=0.18u
Mp389 s389 s388 vdd vdd pch W=1u L=0.18u
Mn390 s390 s389 0 0 nch W=0.5u L=0.18u
Mp390 s390 s389 vdd vdd pch W=1u L=0.18u
Mn391 s391 s390 0 0 nch W=0.5u L=0.18u
Mp391 s391 s390 vdd vdd pch W=1u L=0.18u
Mn392 s392 s391 0 0 nch W=0.5u L=0.18u
Mp392 s392 s391 vdd vdd pch W=1u L=0.18u
Mn393 s393 s392 0 0 nch W=0.5u L=0.18u
Mp393 s393 s392 vdd vdd pch W=1u L=0.18u
Mn394 s394 s393 0 0 nch W=0.5u L=0.18u
Mp394 s394 s393 vdd vdd pch W=1u L=0.18u
Mn395 s395 s394 0 0 nch W=0.5u L=0.18u
Mp395 s395 s394 vdd vdd pch W=1u L=0.18u
Mn396 s396 s395 0 0 nch W=0.5u L=0.18u
Mp396 s396 s395 vdd vdd pch W=1u L=0.18u
Mn397 s397 s396 0 0 nch W=0.5u L=0.18u
Mp397 s397 s396 vdd vdd pch W=1u L=0.18u
Mn398 s398 s397 0 0 nch W=0.5u L=0.18u
Mp398 s398 s397 vdd vdd pch W=1u L=0.18u
Mn399 s399 s398 0 0 nch W=0.5u L=0.18u
Mp399 s399 s398 vdd vdd pch W=1u L=0.18u
Mn400 s400 s399 0 0 nch W=0.5u L=0.18u
Mp400 s400 s399 vdd vdd pch W=1u L=0.18u
Mn401 s401 s400 0 0 nch W=0.5u L=0.18u
Mp401 s401 s400 vdd vdd pch W=1u L=0.18u
Mn402 s402 s401 0 0 nch W=0.5u L=0.18u
Mp402 s402 s401 vdd vdd pch W=1u L=0.18u
Mn403 s403 s402 0 0 nch W=0.5u L=0.18u
Mp403 s403 s402 vdd vdd pch W=1u L=0.18u
Mn404 s404 s403 0 0 nch W=0.5u L=0.18u
Mp404 s404 s403 vdd vdd pch W=1u L=0.18u
Mn405 s405 s404 0 0 nch W=0.5u L=0.18u
Mp405 s405 s404 vdd vdd pch W=1u L=0.18u
Mn406 s406 s405 0 0 nch W=0.5u L=0.18u
Mp406 s406 s405 vdd vdd pch W=1u L=0.18u
Mn407 s407 s406 0 0 nch W=0.5u L=0.18u
Mp407 s407 s406 vdd vdd pch W=1u L=0.18u
Mn408 s408 s407 0 0 nch W=0.5u L=0.18u
Mp408 s408 s407 vdd vdd pch W=1u L=0.18u
Mn409 s409 s408 0 0 nch W=0.5u L=0.18u
Mp409 s409 s408 vdd vdd pch W=1u L=0.18u
Mn410 s410 s409 0 0 nch W=0.5u L=0.18u
Mp410 s410 s409 vdd vdd pch W=1u L=0.18u
Mn411 s411 s410 0 0 nch W=0.5u L=0.18u
Mp411 s411 s410 vdd vdd pch W=1u L=0.18u
Mn412 s412 s411 0 0 nch W=0.5u L=0.18u
Mp412 s412 s411 vdd vdd pch W=1u L=0.18u
Mn413 s413 s412 0 0 nch W=0.5u L=0.18u
Mp413 s413 s412 vdd vdd pch W=1u L=0.18u
Mn414 s414 s413 0 0 nch W=0.5u L=0.18u
Mp414 s414 s413 vdd vdd pch W=1u L=0.18u
Mn415 s415 s414 0 0 nch W=0.5u L=0.18u
Mp415 s415 s414 vdd vdd pch W=1u L=0.18u
Mn416 s416 s415 0 0 nch W=0.5u L=0.18u
Mp416 s416 s415 vdd vdd pch W=1u L=0.18u
Mn417 s417 s416 0 0 nch W=0.5u L=0.18u
Mp417 s417 s416 vdd vdd pch W=1u L=0.18u
Mn418 s418 s417 0 0 nch W=0.5u L=0.18u
Mp418 s418 s417 vdd vdd pch W=1u L=0.18u
Mn419 s419 s418 0 0 nch W=0.5u L=0.18u
Mp419 s419 s418 vdd vdd pch W=1u L=0.18u
Mn420 s420 s419 0 0 nch W=0.5u L=0.18u
Mp420 s420 s419 vdd vdd pch W=1u L=0.18u
Mn421 s421 s420 0 0 nch W=0.5u L=0.18u
Mp421 s421 s420 vdd vdd pch W=1u L=0.18u
Mn422 s422 s421 0 0 nch W=0.5u L=0.18u
Mp422 s422 s421 vdd vdd pch W=1u L=0.18u
Mn423 s423 s422 0 0 nch W=0.5u L=0.18u
Mp423 s423 s422 vdd vdd pch W=1u L=0.18u
Mn424 s424 s423 0 0 nch W=0.5u L=0.18u
Mp424 s424 s423 vdd vdd pch W=1u L=0.18u
Mn425 s425 s424 0 0 nch W=0.5u L=0.18u
Mp425 s425 s424 vdd vdd pch W=1u L=0.18u
Mn426 s426 s425 0 0 nch W=0.5u L=0.18u
Mp426 s426 s425 vdd vdd pch W=1u L=0.18u
Mn427 s427 s426 0 0 nch W=0.5u L=0.18u
Mp427 s427 s426 vdd vdd pch W=1u L=0.18u
Mn428 s428 s427 0 0 nch W=0.5u L=0.18u
Mp428 s428 s427 vdd vdd pch W=1u L=0.18u
Mn429 s429 s428 0 0 nch W=0.5u L=0.18u
Mp429 s429 s428 vdd vdd pch W=1u L=0.18u
Mn430 s430 s429 0 0 nch W=0.5u L=0.18u
Mp430 s430 s429 vdd vdd pch W=1u L=0.18u
Mn431 s431 s430 0 0 nch W=0.5u L=0.18u
Mp431 s431 s430 vdd vdd pch W=1u L=0.18u
Mn432 s432 s431 0 0 nch W=0.5u L=0.18u
Mp432 s432 s431 vdd vdd pch W=1u L=0.18u
Mn433 s433 s432 0 0 nch W=0.5u L=0.18u
Mp433 s433 s432 vdd vdd pch W=1u L=0.18u
Mn434 s434 s433 0 0 nch W=0.5u L=0.18u
Mp434 s434 s433 vdd vdd pch W=1u L=0.18u
Mn435 s435 s434 0 0 nch W=0.5u L=0.18u
Mp435 s435 s434 vdd vdd pch W=1u L=0.18u
Mn436 s436 s435 0 0 nch W=0.5u L=0.18u
Mp436 s436 s435 vdd vdd pch W=1u L=0.18u
Mn437 s437 s436 0 0 nch W=0.5u L=0.18u
Mp437 s437 s436 vdd vdd pch W=1u L=0.18u
Mn438 s438 s437 0 0 nch W=0.5u L=0.18u
Mp438 s438 s437 vdd vdd pch W=1u L=0.18u
Mn439 s439 s438 0 0 nch W=0.5u L=0.18u
Mp439 s439 s438 vdd vdd pch W=1u L=0.18u
Mn440 s440 s439 0 0 nch W=0.5u L=0.18u
Mp440 s440 s439 vdd vdd pch W=1u L=0.18u
Mn441 s441 s440 0 0 nch W=0.5u L=0.18u
Mp441 s441 s440 vdd vdd pch W=1u L=0.18u
Mn442 s442 s441 0 0 nch W=0.5u L=0.18u
Mp442 s442 s441 vdd vdd pch W=1u L=0.18u
Mn443 s443 s442 0 0 nch W=0.5u L=0.18u
Mp443 s443 s442 vdd vdd pch W=1u L=0.18u
Mn444 s444 s443 0 0 nch W=0.5u L=0.18u
Mp444 s444 s443 vdd vdd pch W=1u L=0.18u
Mn445 s445 s444 0 0 nch W=0.5u L=0.18u
Mp445 s445 s444 vdd vdd pch W=1u L=0.18u
Mn446 s446 s445 0 0 nch W=0.5u L=0.18u
Mp446 s446 s445 vdd vdd pch W=1u L=0.18u
Mn447 s447 s446 0 0 nch W=0.5u L=0.18u
Mp447 s447 s446 vdd vdd pch W=1u L=0.18u
Mn448 s448 s447 0 0 nch W=0.5u L=0.18u
Mp448 s448 s447 vdd vdd pch W=1u L=0.18u
Mn449 s449 s448 0 0 nch W=0.5u L=0.18u
Mp449 s449 s448 vdd vdd pch W=1u L=0.18u
Mn450 s450 s449 0 0 nch W=0.5u L=0.18u
Mp450 s450 s449 vdd vdd pch W=1u L=0.18u
Mn451 s451 s450 0 0 nch W=0.5u L=0.18u
Mp451 s451 s450 vdd vdd pch W=1u L=0.18u
Mn452 s452 s451 0 0 nch W=0.5u L=0.18u
Mp452 s452 s451 vdd vdd pch W=1u L=0.18u
Mn453 s453 s452 0 0 nch W=0.5u L=0.18u
Mp453 s453 s452 vdd vdd pch W=1u L=0.18u
Mn454 s454 s453 0 0 nch W=0.5u L=0.18u
Mp454 s454 s453 vdd vdd pch W=1u L=0.18u
Mn455 s455 s454 0 0 nch W=0.5u L=0.18u
Mp455 s455 s454 vdd vdd pch W=1u L=0.18u
Mn456 s456 s455 0 0 nch W=0.5u L=0.18u
Mp456 s456 s455 vdd vdd pch W=1u L=0.18u
Mn457 s457 s456 0 0 nch W=0.5u L=0.18u
Mp457 s457 s456 vdd vdd pch W=1u L=0.18u
Mn458 s458 s457 0 0 nch W=0.5u L=0.18u
Mp458 s458 s457 vdd vdd pch W=1u L=0.18u
Mn459 s459 s458 0 0 nch W=0.5u L=0.18u
Mp459 s459 s458 vdd vdd pch W=1u L=0.18u
Mn460 s460 s459 0 0 nch W=0.5u L=0.18u
Mp460 s460 s459 vdd vdd pch W=1u L=0.18u
Mn461 s461 s460 0 0 nch W=0.5u L=0.18u
Mp461 s461 s460 vdd vdd pch W=1u L=0.18u
Mn462 s462 s461 0 0 nch W=0.5u L=0.18u
Mp462 s462 s461 vdd vdd pch W=1u L=0.18u
Mn463 s463 s462 0 0 nch W=0.5u L=0.18u
Mp463 s463 s462 vdd vdd pch W=1u L=0.18u
Mn464 s464 s463 0 0 nch W=0.5u L=0.18u
Mp464 s464 s463 vdd vdd pch W=1u L=0.18u
Mn465 s465 s464 0 0 nch W=0.5u L=0.18u
Mp465 s465 s464 vdd vdd pch W=1u L=0.18u
Mn466 s466 s465 0 0 nch W=0.5u L=0.18u
Mp466 s466 s465 vdd vdd pch W=1u L=0.18u
Mn467 s467 s466 0 0 nch W=0.5u L=0.18u
Mp467 s467 s466 vdd vdd pch W=1u L=0.18u
Mn468 s468 s467 0 0 nch W=0.5u L=0.18u
Mp468 s468 s467 vdd vdd pch W=1u L=0.18u
Mn469 s469 s468 0 0 nch W=0.5u L=0.18u
Mp469 s469 s468 vdd vdd pch W=1u L=0.18u
Mn470 s470 s469 0 0 nch W=0.5u L=0.18u
Mp470 s470 s469 vdd vdd pch W=1u L=0.18u
Mn471 s471 s470 0 0 nch W=0.5u L=0.18u
Mp471 s471 s470 vdd vdd pch W=1u L=0.18u
Mn472 s472 s471 0 0 nch W=0.5u L=0.18u
Mp472 s472 s471 vdd vdd pch W=1u L=0.18u
Mn473 s473 s472 0 0 nch W=0.5u L=0.18u
Mp473 s473 s472 vdd vdd pch W=1u L=0.18u
Mn474 s474 s473 0 0 nch W=0.5u L=0.18u
Mp474 s474 s473 vdd vdd pch W=1u L=0.18u
Mn475 s475 s474 0 0 nch W=0.5u L=0.18u
Mp475 s475 s474 vdd vdd pch W=1u L=0.18u
Mn476 s476 s475 0 0 nch W=0.5u L=0.18u
Mp476 s476 s475 vdd vdd pch W=1u L=0.18u
Mn477 s477 s476 0 0 nch W=0.5u L=0.18u
Mp477 s477 s476 vdd vdd pch W=1u L=0.18u
Mn478 s478 s477 0 0 nch W=0.5u L=0.18u
Mp478 s478 s477 vdd vdd pch W=1u L=0.18u
Mn479 s479 s478 0 0 nch W=0.5u L=0.18u
Mp479 s479 s478 vdd vdd pch W=1u L=0.18u
Mn480 s480 s479 0 0 nch W=0.5u L=0.18u
Mp480 s480 s479 vdd vdd pch W=1u L=0.18u
Mn481 s481 s480 0 0 nch W=0.5u L=0.18u
Mp481 s481 s480 vdd vdd pch W=1u L=0.18u
Mn482 s482 s481 0 0 nch W=0.5u L=0.18u
Mp482 s482 s481 vdd vdd pch W=1u L=0.18u
Mn483 s483 s482 0 0 nch W=0.5u L=0.18u
Mp483 s483 s482 vdd vdd pch W=1u L=0.18u
Mn484 s484 s483 0 0 nch W=0.5u L=0.18u
Mp484 s484 s483 vdd vdd pch W=1u L=0.18u
Mn485 s485 s484 0 0 nch W=0.5u L=0.18u
Mp485 s485 s484 vdd vdd pch W=1u L=0.18u
Mn486 s486 s485 0 0 nch W=0.5u L=0.18u
Mp486 s486 s485 vdd vdd pch W=1u L=0.18u
Mn487 s487 s486 0 0 nch W=0.5u L=0.18u
Mp487 s487 s486 vdd vdd pch W=1u L=0.18u
Mn488 s488 s487 0 0 nch W=0.5u L=0.18u
Mp488 s488 s487 vdd vdd pch W=1u L=0.18u
Mn489 s489 s488 0 0 nch W=0.5u L=0.18u
Mp489 s489 s488 vdd vdd pch W=1u L=0.18u
Mn490 s490 s489 0 0 nch W=0.5u L=0.18u
Mp490 s490 s489 vdd vdd pch W=1u L=0.18u
Mn491 s491 s490 0 0 nch W=0.5u L=0.18u
Mp491 s491 s490 vdd vdd pch W=1u L=0.18u
Mn492 s492 s491 0 0 nch W=0.5u L=0.18u
Mp492 s492 s491 vdd vdd pch W=1u L=0.18u
Mn493 s493 s492 0 0 nch W=0.5u L=0.18u
Mp493 s493 s492 vdd vdd pch W=1u L=0.18u
Mn494 s494 s493 0 0 nch W=0.5u L=0.18u
Mp494 s494 s493 vdd vdd pch W=1u L=0.18u
Mn495 s495 s494 0 0 nch W=0.5u L=0.18u
Mp495 s495 s494 vdd vdd pch W=1u L=0.18u
Mn496 s496 s495 0 0 nch W=0.5u L=0.18u
Mp496 s496 s495 vdd vdd pch W=1u L=0.18u
Mn497 s497 s496 0 0 nch W=0.5u L=0.18u
Mp497 s497 s496 vdd vdd pch W=1u L=0.18u
Mn498 s498 s497 0 0 nch W=0.5u L=0.18u
Mp498 s498 s497 vdd vdd pch W=1u L=0.18u
Mn499 s499 s498 0 0 nch W=0.5u L=0.18u
Mp499 s499 s498 vdd vdd pch W=1u L=0.18u
Mn500 s500 s499 0 0 nch W=0.5u L=0.18u
Mp500 s500 s499 vdd vdd pch W=1u L=0.18u
Mn501 s501 s500 0 0 nch W=0.5u L=0.18u
Mp501 s501 s500 vdd vdd pch W=1u L=0.18u
Mn502 s502 s501 0 0 nch W=0.5u L=0.18u
Mp502 s502 s501 vdd vdd pch W=1u L=0.18u
Mn503 s503 s502 0 0 nch W=0.5u L=0.18u
Mp503 s503 s502 vdd vdd pch W=1u L=0.18u
Mn504 s504 s503 0 0 nch W=0.5u L=0.18u
Mp504 s504 s503 vdd vdd pch W=1u L=0.18u
Mn505 s505 s504 0 0 nch W=0.5u L=0.18u
Mp505 s505 s504 vdd vdd pch W=1u L=0.18u
Mn506 s506 s505 0 0 nch W=0.5u L=0.18u
Mp506 s506 s505 vdd vdd pch W=1u L=0.18u
Mn507 s507 s506 0 0 nch W=0.5u L=0.18u
Mp507 s507 s506 vdd vdd pch W=1u L=0.18u
Mn508 s508 s507 0 0 nch W=0.5u L=0.18u
Mp508 s508 s507 vdd vdd pch W=1u L=0.18u
Mn509 s509 s508 0 0 nch W=0.5u L=0.18u
Mp509 s509 s508 vdd vdd pch W=1u L=0.18u
Mn510 s510 s509 0 0 nch W=0.5u L=0.18u
Mp510 s510 s509 vdd vdd pch W=1u L=0.18u
Mn511 s511 s510 0 0 nch W=0.5u L=0.18u
Mp511 s511 s510 vdd vdd pch W=1u L=0.18u
Mn512 s512 s511 0 0 nch W=0.5u L=0.18u
Mp512 s512 s511 vdd vdd pch W=1u L=0.18u
Mn513 s513 s512 0 0 nch W=0.5u L=0.18u
Mp513 s513 s512 vdd vdd pch W=1u L=0.18u
Mn514 s514 s513 0 0 nch W=0.5u L=0.18u
Mp514 s514 s513 vdd vdd pch W=1u L=0.18u
Mn515 s515 s514 0 0 nch W=0.5u L=0.18u
Mp515 s515 s514 vdd vdd pch W=1u L=0.18u
Mn516 s516 s515 0 0 nch W=0.5u L=0.18u
Mp516 s516 s515 vdd vdd pch W=1u L=0.18u
Mn517 s517 s516 0 0 nch W=0.5u L=0.18u
Mp517 s517 s516 vdd vdd pch W=1u L=0.18u
Mn518 s518 s517 0 0 nch W=0.5u L=0.18u
Mp518 s518 s517 vdd vdd pch W=1u L=0.18u
Mn519 s519 s518 0 0 nch W=0.5u L=0.18u
Mp519 s519 s518 vdd vdd pch W=1u L=0.18u
Mn520 s520 s519 0 0 nch W=0.5u L=0.18u
Mp520 s520 s519 vdd vdd pch W=1u L=0.18u
Mn521 s521 s520 0 0 nch W=0.5u L=0.18u
Mp521 s521 s520 vdd vdd pch W=1u L=0.18u
Mn522 s522 s521 0 0 nch W=0.5u L=0.18u
Mp522 s522 s521 vdd vdd pch W=1u L=0.18u
Mn523 s523 s522 0 0 nch W=0.5u L=0.18u
Mp523 s523 s522 vdd vdd pch W=1u L=0.18u
Mn524 s524 s523 0 0 nch W=0.5u L=0.18u
Mp524 s524 s523 vdd vdd pch W=1u L=0.18u
Mn525 s525 s524 0 0 nch W=0.5u L=0.18u
Mp525 s525 s524 vdd vdd pch W=1u L=0.18u
Mn526 s526 s525 0 0 nch W=0.5u L=0.18u
Mp526 s526 s525 vdd vdd pch W=1u L=0.18u
Mn527 s527 s526 0 0 nch W=0.5u L=0.18u
Mp527 s527 s526 vdd vdd pch W=1u L=0.18u
Mn528 s528 s527 0 0 nch W=0.5u L=0.18u
Mp528 s528 s527 vdd vdd pch W=1u L=0.18u
Mn529 s529 s528 0 0 nch W=0.5u L=0.18u
Mp529 s529 s528 vdd vdd pch W=1u L=0.18u
Mn530 s530 s529 0 0 nch W=0.5u L=0.18u
Mp530 s530 s529 vdd vdd pch W=1u L=0.18u
Mn531 s531 s530 0 0 nch W=0.5u L=0.18u
Mp531 s531 s530 vdd vdd pch W=1u L=0.18u
Mn532 s532 s531 0 0 nch W=0.5u L=0.18u
Mp532 s532 s531 vdd vdd pch W=1u L=0.18u
Mn533 s533 s532 0 0 nch W=0.5u L=0.18u
Mp533 s533 s532 vdd vdd pch W=1u L=0.18u
Mn534 s534 s533 0 0 nch W=0.5u L=0.18u
Mp534 s534 s533 vdd vdd pch W=1u L=0.18u
Mn535 s535 s534 0 0 nch W=0.5u L=0.18u
Mp535 s535 s534 vdd vdd pch W=1u L=0.18u
Mn536 s536 s535 0 0 nch W=0.5u L=0.18u
Mp536 s536 s535 vdd vdd pch W=1u L=0.18u
Mn537 s537 s536 0 0 nch W=0.5u L=0.18u
Mp537 s537 s536 vdd vdd pch W=1u L=0.18u
Mn538 s538 s537 0 0 nch W=0.5u L=0.18u
Mp538 s538 s537 vdd vdd pch W=1u L=0.18u
Mn539 s539 s538 0 0 nch W=0.5u L=0.18u
Mp539 s539 s538 vdd vdd pch W=1u L=0.18u
Mn540 s540 s539 0 0 nch W=0.5u L=0.18u
Mp540 s540 s539 vdd vdd pch W=1u L=0.18u
Mn541 s541 s540 0 0 nch W=0.5u L=0.18u
Mp541 s541 s540 vdd vdd pch W=1u L=0.18u
Mn542 s542 s541 0 0 nch W=0.5u L=0.18u
Mp542 s542 s541 vdd vdd pch W=1u L=0.18u
Mn543 s543 s542 0 0 nch W=0.5u L=0.18u
Mp543 s543 s542 vdd vdd pch W=1u L=0.18u
Mn544 s544 s543 0 0 nch W=0.5u L=0.18u
Mp544 s544 s543 vdd vdd pch W=1u L=0.18u
Mn545 s545 s544 0 0 nch W=0.5u L=0.18u
Mp545 s545 s544 vdd vdd pch W=1u L=0.18u
Mn546 s546 s545 0 0 nch W=0.5u L=0.18u
Mp546 s546 s545 vdd vdd pch W=1u L=0.18u
Mn547 s547 s546 0 0 nch W=0.5u L=0.18u
Mp547 s547 s546 vdd vdd pch W=1u L=0.18u
Mn548 s548 s547 0 0 nch W=0.5u L=0.18u
Mp548 s548 s547 vdd vdd pch W=1u L=0.18u
Mn549 s549 s548 0 0 nch W=0.5u L=0.18u
Mp549 s549 s548 vdd vdd pch W=1u L=0.18u
Mn550 s550 s549 0 0 nch W=0.5u L=0.18u
Mp550 s550 s549 vdd vdd pch W=1u L=0.18u
Mn551 s551 s550 0 0 nch W=0.5u L=0.18u
Mp551 s551 s550 vdd vdd pch W=1u L=0.18u
Mn552 s552 s551 0 0 nch W=0.5u L=0.18u
Mp552 s552 s551 vdd vdd pch W=1u L=0.18u
Mn553 s553 s552 0 0 nch W=0.5u L=0.18u
Mp553 s553 s552 vdd vdd pch W=1u L=0.18u
Mn554 s554 s553 0 0 nch W=0.5u L=0.18u
Mp554 s554 s553 vdd vdd pch W=1u L=0.18u
Mn555 s555 s554 0 0 nch W=0.5u L=0.18u
Mp555 s555 s554 vdd vdd pch W=1u L=0.18u
Mn556 s556 s555 0 0 nch W=0.5u L=0.18u
Mp556 s556 s555 vdd vdd pch W=1u L=0.18u
Mn557 s557 s556 0 0 nch W=0.5u L=0.18u
Mp557 s557 s556 vdd vdd pch W=1u L=0.18u
Mn558 s558 s557 0 0 nch W=0.5u L=0.18u
Mp558 s558 s557 vdd vdd pch W=1u L=0.18u
Mn559 s559 s558 0 0 nch W=0.5u L=0.18u
Mp559 s559 s558 vdd vdd pch W=1u L=0.18u
Mn560 s560 s559 0 0 nch W=0.5u L=0.18u
Mp560 s560 s559 vdd vdd pch W=1u L=0.18u
Mn561 s561 s560 0 0 nch W=0.5u L=0.18u
Mp561 s561 s560 vdd vdd pch W=1u L=0.18u
Mn562 s562 s561 0 0 nch W=0.5u L=0.18u
Mp562 s562 s561 vdd vdd pch W=1u L=0.18u
Mn563 s563 s562 0 0 nch W=0.5u L=0.18u
Mp563 s563 s562 vdd vdd pch W=1u L=0.18u
Mn564 s564 s563 0 0 nch W=0.5u L=0.18u
Mp564 s564 s563 vdd vdd pch W=1u L=0.18u
Mn565 s565 s564 0 0 nch W=0.5u L=0.18u
Mp565 s565 s564 vdd vdd pch W=1u L=0.18u
Mn566 s566 s565 0 0 nch W=0.5u L=0.18u
Mp566 s566 s565 vdd vdd pch W=1u L=0.18u
Mn567 s567 s566 0 0 nch W=0.5u L=0.18u
Mp567 s567 s566 vdd vdd pch W=1u L=0.18u
Mn568 s568 s567 0 0 nch W=0.5u L=0.18u
Mp568 s568 s567 vdd vdd pch W=1u L=0.18u
Mn569 s569 s568 0 0 nch W=0.5u L=0.18u
Mp569 s569 s568 vdd vdd pch W=1u L=0.18u
Mn570 s570 s569 0 0 nch W=0.5u L=0.18u
Mp570 s570 s569 vdd vdd pch W=1u L=0.18u
Mn571 s571 s570 0 0 nch W=0.5u L=0.18u
Mp571 s571 s570 vdd vdd pch W=1u L=0.18u
Mn572 s572 s571 0 0 nch W=0.5u L=0.18u
Mp572 s572 s571 vdd vdd pch W=1u L=0.18u
Mn573 s573 s572 0 0 nch W=0.5u L=0.18u
Mp573 s573 s572 vdd vdd pch W=1u L=0.18u
Mn574 s574 s573 0 0 nch W=0.5u L=0.18u
Mp574 s574 s573 vdd vdd pch W=1u L=0.18u
Mn575 s575 s574 0 0 nch W=0.5u L=0.18u
Mp575 s575 s574 vdd vdd pch W=1u L=0.18u
Mn576 s576 s575 0 0 nch W=0.5u L=0.18u
Mp576 s576 s575 vdd vdd pch W=1u L=0.18u
Mn577 s577 s576 0 0 nch W=0.5u L=0.18u
Mp577 s577 s576 vdd vdd pch W=1u L=0.18u
Mn578 s578 s577 0 0 nch W=0.5u L=0.18u
Mp578 s578 s577 vdd vdd pch W=1u L=0.18u
Mn579 s579 s578 0 0 nch W=0.5u L=0.18u
Mp579 s579 s578 vdd vdd pch W=1u L=0.18u
Mn580 s580 s579 0 0 nch W=0.5u L=0.18u
Mp580 s580 s579 vdd vdd pch W=1u L=0.18u
Mn581 s581 s580 0 0 nch W=0.5u L=0.18u
Mp581 s581 s580 vdd vdd pch W=1u L=0.18u
Mn582 s582 s581 0 0 nch W=0.5u L=0.18u
Mp582 s582 s581 vdd vdd pch W=1u L=0.18u
Mn583 s583 s582 0 0 nch W=0.5u L=0.18u
Mp583 s583 s582 vdd vdd pch W=1u L=0.18u
Mn584 s584 s583 0 0 nch W=0.5u L=0.18u
Mp584 s584 s583 vdd vdd pch W=1u L=0.18u
Mn585 s585 s584 0 0 nch W=0.5u L=0.18u
Mp585 s585 s584 vdd vdd pch W=1u L=0.18u
Mn586 s586 s585 0 0 nch W=0.5u L=0.18u
Mp586 s586 s585 vdd vdd pch W=1u L=0.18u
Mn587 s587 s586 0 0 nch W=0.5u L=0.18u
Mp587 s587 s586 vdd vdd pch W=1u L=0.18u
Mn588 s588 s587 0 0 nch W=0.5u L=0.18u
Mp588 s588 s587 vdd vdd pch W=1u L=0.18u
Mn589 s589 s588 0 0 nch W=0.5u L=0.18u
Mp589 s589 s588 vdd vdd pch W=1u L=0.18u
Mn590 s590 s589 0 0 nch W=0.5u L=0.18u
Mp590 s590 s589 vdd vdd pch W=1u L=0.18u
Mn591 s591 s590 0 0 nch W=0.5u L=0.18u
Mp591 s591 s590 vdd vdd pch W=1u L=0.18u
Mn592 s592 s591 0 0 nch W=0.5u L=0.18u
Mp592 s592 s591 vdd vdd pch W=1u L=0.18u
Mn593 s593 s592 0 0 nch W=0.5u L=0.18u
Mp593 s593 s592 vdd vdd pch W=1u L=0.18u
Mn594 s594 s593 0 0 nch W=0.5u L=0.18u
Mp594 s594 s593 vdd vdd pch W=1u L=0.18u
Mn595 s595 s594 0 0 nch W=0.5u L=0.18u
Mp595 s595 s594 vdd vdd pch W=1u L=0.18u
Mn596 s596 s595 0 0 nch W=0.5u L=0.18u
Mp596 s596 s595 vdd vdd pch W=1u L=0.18u
Mn597 s597 s596 0 0 nch W=0.5u L=0.18u
Mp597 s597 s596 vdd vdd pch W=1u L=0.18u
Mn598 s598 s597 0 0 nch W=0.5u L=0.18u
Mp598 s598 s597 vdd vdd pch W=1u L=0.18u
Mn599 s599 s598 0 0 nch W=0.5u L=0.18u
Mp599 s599 s598 vdd vdd pch W=1u L=0.18u
Mn600 s600 s599 0 0 nch W=0.5u L=0.18u
Mp600 s600 s599 vdd vdd pch W=1u L=0.18u
Mn601 s601 s600 0 0 nch W=0.5u L=0.18u
Mp601 s601 s600 vdd vdd pch W=1u L=0.18u
Mn602 s602 s601 0 0 nch W=0.5u L=0.18u
Mp602 s602 s601 vdd vdd pch W=1u L=0.18u
Mn603 s603 s602 0 0 nch W=0.5u L=0.18u
Mp603 s603 s602 vdd vdd pch W=1u L=0.18u
Mn604 s604 s603 0 0 nch W=0.5u L=0.18u
Mp604 s604 s603 vdd vdd pch W=1u L=0.18u
Mn605 s605 s604 0 0 nch W=0.5u L=0.18u
Mp605 s605 s604 vdd vdd pch W=1u L=0.18u
Mn606 s606 s605 0 0 nch W=0.5u L=0.18u
Mp606 s606 s605 vdd vdd pch W=1u L=0.18u
Mn607 s607 s606 0 0 nch W=0.5u L=0.18u
Mp607 s607 s606 vdd vdd pch W=1u L=0.18u
Mn608 s608 s607 0 0 nch W=0.5u L=0.18u
Mp608 s608 s607 vdd vdd pch W=1u L=0.18u
Mn609 s609 s608 0 0 nch W=0.5u L=0.18u
Mp609 s609 s608 vdd vdd pch W=1u L=0.18u
Mn610 s610 s609 0 0 nch W=0.5u L=0.18u
Mp610 s610 s609 vdd vdd pch W=1u L=0.18u
Mn611 s611 s610 0 0 nch W=0.5u L=0.18u
Mp611 s611 s610 vdd vdd pch W=1u L=0.18u
Mn612 s612 s611 0 0 nch W=0.5u L=0.18u
Mp612 s612 s611 vdd vdd pch W=1u L=0.18u
Mn613 s613 s612 0 0 nch W=0.5u L=0.18u
Mp613 s613 s612 vdd vdd pch W=1u L=0.18u
Mn614 s614 s613 0 0 nch W=0.5u L=0.18u
Mp614 s614 s613 vdd vdd pch W=1u L=0.18u
Mn615 s615 s614 0 0 nch W=0.5u L=0.18u
Mp615 s615 s614 vdd vdd pch W=1u L=0.18u
Mn616 s616 s615 0 0 nch W=0.5u L=0.18u
Mp616 s616 s615 vdd vdd pch W=1u L=0.18u
Mn617 s617 s616 0 0 nch W=0.5u L=0.18u
Mp617 s617 s616 vdd vdd pch W=1u L=0.18u
Mn618 s618 s617 0 0 nch W=0.5u L=0.18u
Mp618 s618 s617 vdd vdd pch W=1u L=0.18u
Mn619 s619 s618 0 0 nch W=0.5u L=0.18u
Mp619 s619 s618 vdd vdd pch W=1u L=0.18u
Mn620 s620 s619 0 0 nch W=0.5u L=0.18u
Mp620 s620 s619 vdd vdd pch W=1u L=0.18u
Mn621 s621 s620 0 0 nch W=0.5u L=0.18u
Mp621 s621 s620 vdd vdd pch W=1u L=0.18u
Mn622 s622 s621 0 0 nch W=0.5u L=0.18u
Mp622 s622 s621 vdd vdd pch W=1u L=0.18u
Mn623 s623 s622 0 0 nch W=0.5u L=0.18u
Mp623 s623 s622 vdd vdd pch W=1u L=0.18u
Mn624 s624 s623 0 0 nch W=0.5u L=0.18u
Mp624 s624 s623 vdd vdd pch W=1u L=0.18u
Mn625 s625 s624 0 0 nch W=0.5u L=0.18u
Mp625 s625 s624 vdd vdd pch W=1u L=0.18u
Mn626 s626 s625 0 0 nch W=0.5u L=0.18u
Mp626 s626 s625 vdd vdd pch W=1u L=0.18u
Mn627 s627 s626 0 0 nch W=0.5u L=0.18u
Mp627 s627 s626 vdd vdd pch W=1u L=0.18u
Mn628 s628 s627 0 0 nch W=0.5u L=0.18u
Mp628 s628 s627 vdd vdd pch W=1u L=0.18u
Mn629 s629 s628 0 0 nch W=0.5u L=0.18u
Mp629 s629 s628 vdd vdd pch W=1u L=0.18u
Mn630 s630 s629 0 0 nch W=0.5u L=0.18u
Mp630 s630 s629 vdd vdd pch W=1u L=0.18u
Mn631 s631 s630 0 0 nch W=0.5u L=0.18u
Mp631 s631 s630 vdd vdd pch W=1u L=0.18u
Mn632 s632 s631 0 0 nch W=0.5u L=0.18u
Mp632 s632 s631 vdd vdd pch W=1u L=0.18u
Mn633 s633 s632 0 0 nch W=0.5u L=0.18u
Mp633 s633 s632 vdd vdd pch W=1u L=0.18u
Mn634 s634 s633 0 0 nch W=0.5u L=0.18u
Mp634 s634 s633 vdd vdd pch W=1u L=0.18u
Mn635 s635 s634 0 0 nch W=0.5u L=0.18u
Mp635 s635 s634 vdd vdd pch W=1u L=0.18u
Mn636 s636 s635 0 0 nch W=0.5u L=0.18u
Mp636 s636 s635 vdd vdd pch W=1u L=0.18u
Mn637 s637 s636 0 0 nch W=0.5u L=0.18u
Mp637 s637 s636 vdd vdd pch W=1u L=0.18u
Mn638 s638 s637 0 0 nch W=0.5u L=0.18u
Mp638 s638 s637 vdd vdd pch W=1u L=0.18u
Mn639 s639 s638 0 0 nch W=0.5u L=0.18u
Mp639 s639 s638 vdd vdd pch W=1u L=0.18u
Mn640 s640 s639 0 0 nch W=0.5u L=0.18u
Mp640 s640 s639 vdd vdd pch W=1u L=0.18u
Mn641 s641 s640 0 0 nch W=0.5u L=0.18u
Mp641 s641 s640 vdd vdd pch W=1u L=0.18u
Mn642 s642 s641 0 0 nch W=0.5u L=0.18u
Mp642 s642 s641 vdd vdd pch W=1u L=0.18u
Mn643 s643 s642 0 0 nch W=0.5u L=0.18u
Mp643 s643 s642 vdd vdd pch W=1u L=0.18u
Mn644 s644 s643 0 0 nch W=0.5u L=0.18u
Mp644 s644 s643 vdd vdd pch W=1u L=0.18u
Mn645 s645 s644 0 0 nch W=0.5u L=0.18u
Mp645 s645 s644 vdd vdd pch W=1u L=0.18u
Mn646 s646 s645 0 0 nch W=0.5u L=0.18u
Mp646 s646 s645 vdd vdd pch W=1u L=0.18u
Mn647 s647 s646 0 0 nch W=0.5u L=0.18u
Mp647 s647 s646 vdd vdd pch W=1u L=0.18u
Mn648 s648 s647 0 0 nch W=0.5u L=0.18u
Mp648 s648 s647 vdd vdd pch W=1u L=0.18u
Mn649 s649 s648 0 0 nch W=0.5u L=0.18u
Mp649 s649 s648 vdd vdd pch W=1u L=0.18u
Mn650 s650 s649 0 0 nch W=0.5u L=0.18u
Mp650 s650 s649 vdd vdd pch W=1u L=0.18u
Mn651 s651 s650 0 0 nch W=0.5u L=0.18u
Mp651 s651 s650 vdd vdd pch W=1u L=0.18u
Mn652 s652 s651 0 0 nch W=0.5u L=0.18u
Mp652 s652 s651 vdd vdd pch W=1u L=0.18u
Mn653 s653 s652 0 0 nch W=0.5u L=0.18u
Mp653 s653 s652 vdd vdd pch W=1u L=0.18u
Mn654 s654 s653 0 0 nch W=0.5u L=0.18u
Mp654 s654 s653 vdd vdd pch W=1u L=0.18u
Mn655 s655 s654 0 0 nch W=0.5u L=0.18u
Mp655 s655 s654 vdd vdd pch W=1u L=0.18u
Mn656 s656 s655 0 0 nch W=0.5u L=0.18u
Mp656 s656 s655 vdd vdd pch W=1u L=0.18u
Mn657 s657 s656 0 0 nch W=0.5u L=0.18u
Mp657 s657 s656 vdd vdd pch W=1u L=0.18u
Mn658 s658 s657 0 0 nch W=0.5u L=0.18u
Mp658 s658 s657 vdd vdd pch W=1u L=0.18u
Mn659 s659 s658 0 0 nch W=0.5u L=0.18u
Mp659 s659 s658 vdd vdd pch W=1u L=0.18u
Mn660 s660 s659 0 0 nch W=0.5u L=0.18u
Mp660 s660 s659 vdd vdd pch W=1u L=0.18u
Mn661 s661 s660 0 0 nch W=0.5u L=0.18u
Mp661 s661 s660 vdd vdd pch W=1u L=0.18u
Mn662 s662 s661 0 0 nch W=0.5u L=0.18u
Mp662 s662 s661 vdd vdd pch W=1u L=0.18u
Mn663 s663 s662 0 0 nch W=0.5u L=0.18u
Mp663 s663 s662 vdd vdd pch W=1u L=0.18u
Mn664 s664 s663 0 0 nch W=0.5u L=0.18u
Mp664 s664 s663 vdd vdd pch W=1u L=0.18u
Mn665 s665 s664 0 0 nch W=0.5u L=0.18u
Mp665 s665 s664 vdd vdd pch W=1u L=0.18u
Mn666 s666 s665 0 0 nch W=0.5u L=0.18u
Mp666 s666 s665 vdd vdd pch W=1u L=0.18u
Mn667 s667 s666 0 0 nch W=0.5u L=0.18u
Mp667 s667 s666 vdd vdd pch W=1u L=0.18u
Mn668 s668 s667 0 0 nch W=0.5u L=0.18u
Mp668 s668 s667 vdd vdd pch W=1u L=0.18u
Mn669 s669 s668 0 0 nch W=0.5u L=0.18u
Mp669 s669 s668 vdd vdd pch W=1u L=0.18u
Mn670 s670 s669 0 0 nch W=0.5u L=0.18u
Mp670 s670 s669 vdd vdd pch W=1u L=0.18u
Mn671 s671 s670 0 0 nch W=0.5u L=0.18u
Mp671 s671 s670 vdd vdd pch W=1u L=0.18u
Mn672 s672 s671 0 0 nch W=0.5u L=0.18u
Mp672 s672 s671 vdd vdd pch W=1u L=0.18u
Mn673 s673 s672 0 0 nch W=0.5u L=0.18u
Mp673 s673 s672 vdd vdd pch W=1u L=0.18u
Mn674 s674 s673 0 0 nch W=0.5u L=0.18u
Mp674 s674 s673 vdd vdd pch W=1u L=0.18u
Mn675 s675 s674 0 0 nch W=0.5u L=0.18u
Mp675 s675 s674 vdd vdd pch W=1u L=0.18u
Mn676 s676 s675 0 0 nch W=0.5u L=0.18u
Mp676 s676 s675 vdd vdd pch W=1u L=0.18u
Mn677 s677 s676 0 0 nch W=0.5u L=0.18u
Mp677 s677 s676 vdd vdd pch W=1u L=0.18u
Mn678 s678 s677 0 0 nch W=0.5u L=0.18u
Mp678 s678 s677 vdd vdd pch W=1u L=0.18u
Mn679 s679 s678 0 0 nch W=0.5u L=0.18u
Mp679 s679 s678 vdd vdd pch W=1u L=0.18u
Mn680 s680 s679 0 0 nch W=0.5u L=0.18u
Mp680 s680 s679 vdd vdd pch W=1u L=0.18u
Mn681 s681 s680 0 0 nch W=0.5u L=0.18u
Mp681 s681 s680 vdd vdd pch W=1u L=0.18u
Mn682 s682 s681 0 0 nch W=0.5u L=0.18u
Mp682 s682 s681 vdd vdd pch W=1u L=0.18u
Mn683 s683 s682 0 0 nch W=0.5u L=0.18u
Mp683 s683 s682 vdd vdd pch W=1u L=0.18u
Mn684 s684 s683 0 0 nch W=0.5u L=0.18u
Mp684 s684 s683 vdd vdd pch W=1u L=0.18u
Mn685 s685 s684 0 0 nch W=0.5u L=0.18u
Mp685 s685 s684 vdd vdd pch W=1u L=0.18u
Mn686 s686 s685 0 0 nch W=0.5u L=0.18u
Mp686 s686 s685 vdd vdd pch W=1u L=0.18u
Mn687 s687 s686 0 0 nch W=0.5u L=0.18u
Mp687 s687 s686 vdd vdd pch W=1u L=0.18u
Mn688 s688 s687 0 0 nch W=0.5u L=0.18u
Mp688 s688 s687 vdd vdd pch W=1u L=0.18u
Mn689 s689 s688 0 0 nch W=0.5u L=0.18u
Mp689 s689 s688 vdd vdd pch W=1u L=0.18u
Mn690 s690 s689 0 0 nch W=0.5u L=0.18u
Mp690 s690 s689 vdd vdd pch W=1u L=0.18u
Mn691 s691 s690 0 0 nch W=0.5u L=0.18u
Mp691 s691 s690 vdd vdd pch W=1u L=0.18u
Mn692 s692 s691 0 0 nch W=0.5u L=0.18u
Mp692 s692 s691 vdd vdd pch W=1u L=0.18u
Mn693 s693 s692 0 0 nch W=0.5u L=0.18u
Mp693 s693 s692 vdd vdd pch W=1u L=0.18u
Mn694 s694 s693 0 0 nch W=0.5u L=0.18u
Mp694 s694 s693 vdd vdd pch W=1u L=0.18u
Mn695 s695 s694 0 0 nch W=0.5u L=0.18u
Mp695 s695 s694 vdd vdd pch W=1u L=0.18u
Mn696 s696 s695 0 0 nch W=0.5u L=0.18u
Mp696 s696 s695 vdd vdd pch W=1u L=0.18u
Mn697 s697 s696 0 0 nch W=0.5u L=0.18u
Mp697 s697 s696 vdd vdd pch W=1u L=0.18u
Mn698 s698 s697 0 0 nch W=0.5u L=0.18u
Mp698 s698 s697 vdd vdd pch W=1u L=0.18u
Mn699 s699 s698 0 0 nch W=0.5u L=0.18u
Mp699 s699 s698 vdd vdd pch W=1u L=0.18u
Mn700 s700 s699 0 0 nch W=0.5u L=0.18u
Mp700 s700 s699 vdd vdd pch W=1u L=0.18u
Mn701 s701 s700 0 0 nch W=0.5u L=0.18u
Mp701 s701 s700 vdd vdd pch W=1u L=0.18u
Mn702 s702 s701 0 0 nch W=0.5u L=0.18u
Mp702 s702 s701 vdd vdd pch W=1u L=0.18u
Mn703 s703 s702 0 0 nch W=0.5u L=0.18u
Mp703 s703 s702 vdd vdd pch W=1u L=0.18u
Mn704 s704 s703 0 0 nch W=0.5u L=0.18u
Mp704 s704 s703 vdd vdd pch W=1u L=0.18u
Mn705 s705 s704 0 0 nch W=0.5u L=0.18u
Mp705 s705 s704 vdd vdd pch W=1u L=0.18u
Mn706 s706 s705 0 0 nch W=0.5u L=0.18u
Mp706 s706 s705 vdd vdd pch W=1u L=0.18u
Mn707 s707 s706 0 0 nch W=0.5u L=0.18u
Mp707 s707 s706 vdd vdd pch W=1u L=0.18u
Mn708 s708 s707 0 0 nch W=0.5u L=0.18u
Mp708 s708 s707 vdd vdd pch W=1u L=0.18u
Mn709 s709 s708 0 0 nch W=0.5u L=0.18u
Mp709 s709 s708 vdd vdd pch W=1u L=0.18u
Mn710 s710 s709 0 0 nch W=0.5u L=0.18u
Mp710 s710 s709 vdd vdd pch W=1u L=0.18u
Mn711 s711 s710 0 0 nch W=0.5u L=0.18u
Mp711 s711 s710 vdd vdd pch W=1u L=0.18u
Mn712 s712 s711 0 0 nch W=0.5u L=0.18u
Mp712 s712 s711 vdd vdd pch W=1u L=0.18u
Mn713 s713 s712 0 0 nch W=0.5u L=0.18u
Mp713 s713 s712 vdd vdd pch W=1u L=0.18u
Mn714 s714 s713 0 0 nch W=0.5u L=0.18u
Mp714 s714 s713 vdd vdd pch W=1u L=0.18u
Mn715 s715 s714 0 0 nch W=0.5u L=0.18u
Mp715 s715 s714 vdd vdd pch W=1u L=0.18u
Mn716 s716 s715 0 0 nch W=0.5u L=0.18u
Mp716 s716 s715 vdd vdd pch W=1u L=0.18u
Mn717 s717 s716 0 0 nch W=0.5u L=0.18u
Mp717 s717 s716 vdd vdd pch W=1u L=0.18u
Mn718 s718 s717 0 0 nch W=0.5u L=0.18u
Mp718 s718 s717 vdd vdd pch W=1u L=0.18u
Mn719 s719 s718 0 0 nch W=0.5u L=0.18u
Mp719 s719 s718 vdd vdd pch W=1u L=0.18u
Mn720 s720 s719 0 0 nch W=0.5u L=0.18u
Mp720 s720 s719 vdd vdd pch W=1u L=0.18u
Mn721 s721 s720 0 0 nch W=0.5u L=0.18u
Mp721 s721 s720 vdd vdd pch W=1u L=0.18u
Mn722 s722 s721 0 0 nch W=0.5u L=0.18u
Mp722 s722 s721 vdd vdd pch W=1u L=0.18u
Mn723 s723 s722 0 0 nch W=0.5u L=0.18u
Mp723 s723 s722 vdd vdd pch W=1u L=0.18u
Mn724 s724 s723 0 0 nch W=0.5u L=0.18u
Mp724 s724 s723 vdd vdd pch W=1u L=0.18u
Mn725 s725 s724 0 0 nch W=0.5u L=0.18u
Mp725 s725 s724 vdd vdd pch W=1u L=0.18u
Mn726 s726 s725 0 0 nch W=0.5u L=0.18u
Mp726 s726 s725 vdd vdd pch W=1u L=0.18u
Mn727 s727 s726 0 0 nch W=0.5u L=0.18u
Mp727 s727 s726 vdd vdd pch W=1u L=0.18u
Mn728 s728 s727 0 0 nch W=0.5u L=0.18u
Mp728 s728 s727 vdd vdd pch W=1u L=0.18u
Mn729 s729 s728 0 0 nch W=0.5u L=0.18u
Mp729 s729 s728 vdd vdd pch W=1u L=0.18u
Mn730 s730 s729 0 0 nch W=0.5u L=0.18u
Mp730 s730 s729 vdd vdd pch W=1u L=0.18u
Mn731 s731 s730 0 0 nch W=0.5u L=0.18u
Mp731 s731 s730 vdd vdd pch W=1u L=0.18u
Mn732 s732 s731 0 0 nch W=0.5u L=0.18u
Mp732 s732 s731 vdd vdd pch W=1u L=0.18u
Mn733 s733 s732 0 0 nch W=0.5u L=0.18u
Mp733 s733 s732 vdd vdd pch W=1u L=0.18u
Mn734 s734 s733 0 0 nch W=0.5u L=0.18u
Mp734 s734 s733 vdd vdd pch W=1u L=0.18u
Mn735 s735 s734 0 0 nch W=0.5u L=0.18u
Mp735 s735 s734 vdd vdd pch W=1u L=0.18u
Mn736 s736 s735 0 0 nch W=0.5u L=0.18u
Mp736 s736 s735 vdd vdd pch W=1u L=0.18u
Mn737 s737 s736 0 0 nch W=0.5u L=0.18u
Mp737 s737 s736 vdd vdd pch W=1u L=0.18u
Mn738 s738 s737 0 0 nch W=0.5u L=0.18u
Mp738 s738 s737 vdd vdd pch W=1u L=0.18u
Mn739 s739 s738 0 0 nch W=0.5u L=0.18u
Mp739 s739 s738 vdd vdd pch W=1u L=0.18u
Mn740 s740 s739 0 0 nch W=0.5u L=0.18u
Mp740 s740 s739 vdd vdd pch W=1u L=0.18u
Mn741 s741 s740 0 0 nch W=0.5u L=0.18u
Mp741 s741 s740 vdd vdd pch W=1u L=0.18u
Mn742 s742 s741 0 0 nch W=0.5u L=0.18u
Mp742 s742 s741 vdd vdd pch W=1u L=0.18u
Mn743 s743 s742 0 0 nch W=0.5u L=0.18u
Mp743 s743 s742 vdd vdd pch W=1u L=0.18u
Mn744 s744 s743 0 0 nch W=0.5u L=0.18u
Mp744 s744 s743 vdd vdd pch W=1u L=0.18u
Mn745 s745 s744 0 0 nch W=0.5u L=0.18u
Mp745 s745 s744 vdd vdd pch W=1u L=0.18u
Mn746 s746 s745 0 0 nch W=0.5u L=0.18u
Mp746 s746 s745 vdd vdd pch W=1u L=0.18u
Mn747 s747 s746 0 0 nch W=0.5u L=0.18u
Mp747 s747 s746 vdd vdd pch W=1u L=0.18u
Mn748 s748 s747 0 0 nch W=0.5u L=0.18u
Mp748 s748 s747 vdd vdd pch W=1u L=0.18u
Mn749 s749 s748 0 0 nch W=0.5u L=0.18u
Mp749 s749 s748 vdd vdd pch W=1u L=0.18u
Mn750 s750 s749 0 0 nch W=0.5u L=0.18u
Mp750 s750 s749 vdd vdd pch W=1u L=0.18u
Mn751 s751 s750 0 0 nch W=0.5u L=0.18u
Mp751 s751 s750 vdd vdd pch W=1u L=0.18u
Mn752 s752 s751 0 0 nch W=0.5u L=0.18u
Mp752 s752 s751 vdd vdd pch W=1u L=0.18u
Mn753 s753 s752 0 0 nch W=0.5u L=0.18u
Mp753 s753 s752 vdd vdd pch W=1u L=0.18u
Mn754 s754 s753 0 0 nch W=0.5u L=0.18u
Mp754 s754 s753 vdd vdd pch W=1u L=0.18u
Mn755 s755 s754 0 0 nch W=0.5u L=0.18u
Mp755 s755 s754 vdd vdd pch W=1u L=0.18u
Mn756 s756 s755 0 0 nch W=0.5u L=0.18u
Mp756 s756 s755 vdd vdd pch W=1u L=0.18u
Mn757 s757 s756 0 0 nch W=0.5u L=0.18u
Mp757 s757 s756 vdd vdd pch W=1u L=0.18u
Mn758 s758 s757 0 0 nch W=0.5u L=0.18u
Mp758 s758 s757 vdd vdd pch W=1u L=0.18u
Mn759 s759 s758 0 0 nch W=0.5u L=0.18u
Mp759 s759 s758 vdd vdd pch W=1u L=0.18u
Mn760 s760 s759 0 0 nch W=0.5u L=0.18u
Mp760 s760 s759 vdd vdd pch W=1u L=0.18u
Mn761 s761 s760 0 0 nch W=0.5u L=0.18u
Mp761 s761 s760 vdd vdd pch W=1u L=0.18u
Mn762 s762 s761 0 0 nch W=0.5u L=0.18u
Mp762 s762 s761 vdd vdd pch W=1u L=0.18u
Mn763 s763 s762 0 0 nch W=0.5u L=0.18u
Mp763 s763 s762 vdd vdd pch W=1u L=0.18u
Mn764 s764 s763 0 0 nch W=0.5u L=0.18u
Mp764 s764 s763 vdd vdd pch W=1u L=0.18u
Mn765 s765 s764 0 0 nch W=0.5u L=0.18u
Mp765 s765 s764 vdd vdd pch W=1u L=0.18u
Mn766 s766 s765 0 0 nch W=0.5u L=0.18u
Mp766 s766 s765 vdd vdd pch W=1u L=0.18u
Mn767 s767 s766 0 0 nch W=0.5u L=0.18u
Mp767 s767 s766 vdd vdd pch W=1u L=0.18u
Mn768 s768 s767 0 0 nch W=0.5u L=0.18u
Mp768 s768 s767 vdd vdd pch W=1u L=0.18u
Mn769 s769 s768 0 0 nch W=0.5u L=0.18u
Mp769 s769 s768 vdd vdd pch W=1u L=0.18u
Mn770 s770 s769 0 0 nch W=0.5u L=0.18u
Mp770 s770 s769 vdd vdd pch W=1u L=0.18u
Mn771 s771 s770 0 0 nch W=0.5u L=0.18u
Mp771 s771 s770 vdd vdd pch W=1u L=0.18u
Mn772 s772 s771 0 0 nch W=0.5u L=0.18u
Mp772 s772 s771 vdd vdd pch W=1u L=0.18u
Mn773 s773 s772 0 0 nch W=0.5u L=0.18u
Mp773 s773 s772 vdd vdd pch W=1u L=0.18u
Mn774 s774 s773 0 0 nch W=0.5u L=0.18u
Mp774 s774 s773 vdd vdd pch W=1u L=0.18u
Mn775 s775 s774 0 0 nch W=0.5u L=0.18u
Mp775 s775 s774 vdd vdd pch W=1u L=0.18u
Mn776 s776 s775 0 0 nch W=0.5u L=0.18u
Mp776 s776 s775 vdd vdd pch W=1u L=0.18u
Mn777 s777 s776 0 0 nch W=0.5u L=0.18u
Mp777 s777 s776 vdd vdd pch W=1u L=0.18u
Mn778 s778 s777 0 0 nch W=0.5u L=0.18u
Mp778 s778 s777 vdd vdd pch W=1u L=0.18u
Mn779 s779 s778 0 0 nch W=0.5u L=0.18u
Mp779 s779 s778 vdd vdd pch W=1u L=0.18u
Mn780 s780 s779 0 0 nch W=0.5u L=0.18u
Mp780 s780 s779 vdd vdd pch W=1u L=0.18u
Mn781 s781 s780 0 0 nch W=0.5u L=0.18u
Mp781 s781 s780 vdd vdd pch W=1u L=0.18u
Mn782 s782 s781 0 0 nch W=0.5u L=0.18u
Mp782 s782 s781 vdd vdd pch W=1u L=0.18u
Mn783 s783 s782 0 0 nch W=0.5u L=0.18u
Mp783 s783 s782 vdd vdd pch W=1u L=0.18u
Mn784 s784 s783 0 0 nch W=0.5u L=0.18u
Mp784 s784 s783 vdd vdd pch W=1u L=0.18u
Mn785 s785 s784 0 0 nch W=0.5u L=0.18u
Mp785 s785 s784 vdd vdd pch W=1u L=0.18u
Mn786 s786 s785 0 0 nch W=0.5u L=0.18u
Mp786 s786 s785 vdd vdd pch W=1u L=0.18u
Mn787 s787 s786 0 0 nch W=0.5u L=0.18u
Mp787 s787 s786 vdd vdd pch W=1u L=0.18u
Mn788 s788 s787 0 0 nch W=0.5u L=0.18u
Mp788 s788 s787 vdd vdd pch W=1u L=0.18u
Mn789 s789 s788 0 0 nch W=0.5u L=0.18u
Mp789 s789 s788 vdd vdd pch W=1u L=0.18u
Mn790 s790 s789 0 0 nch W=0.5u L=0.18u
Mp790 s790 s789 vdd vdd pch W=1u L=0.18u
Mn791 s791 s790 0 0 nch W=0.5u L=0.18u
Mp791 s791 s790 vdd vdd pch W=1u L=0.18u
Mn792 s792 s791 0 0 nch W=0.5u L=0.18u
Mp792 s792 s791 vdd vdd pch W=1u L=0.18u
Mn793 s793 s792 0 0 nch W=0.5u L=0.18u
Mp793 s793 s792 vdd vdd pch W=1u L=0.18u
Mn794 s794 s793 0 0 nch W=0.5u L=0.18u
Mp794 s794 s793 vdd vdd pch W=1u L=0.18u
Mn795 s795 s794 0 0 nch W=0.5u L=0.18u
Mp795 s795 s794 vdd vdd pch W=1u L=0.18u
Mn796 s796 s795 0 0 nch W=0.5u L=0.18u
Mp796 s796 s795 vdd vdd pch W=1u L=0.18u
Mn797 s797 s796 0 0 nch W=0.5u L=0.18u
Mp797 s797 s796 vdd vdd pch W=1u L=0.18u
Mn798 s798 s797 0 0 nch W=0.5u L=0.18u
Mp798 s798 s797 vdd vdd pch W=1u L=0.18u
Mn799 s799 s798 0 0 nch W=0.5u L=0.18u
Mp799 s799 s798 vdd vdd pch W=1u L=0.18u
Mn800 s800 s799 0 0 nch W=0.5u L=0.18u
Mp800 s800 s799 vdd vdd pch W=1u L=0.18u
Mn801 s801 s800 0 0 nch W=0.5u L=0.18u
Mp801 s801 s800 vdd vdd pch W=1u L=0.18u
Mn802 s802 s801 0 0 nch W=0.5u L=0.18u
Mp802 s802 s801 vdd vdd pch W=1u L=0.18u
Mn803 s803 s802 0 0 nch W=0.5u L=0.18u
Mp803 s803 s802 vdd vdd pch W=1u L=0.18u
Mn804 s804 s803 0 0 nch W=0.5u L=0.18u
Mp804 s804 s803 vdd vdd pch W=1u L=0.18u
Mn805 s805 s804 0 0 nch W=0.5u L=0.18u
Mp805 s805 s804 vdd vdd pch W=1u L=0.18u
Mn806 s806 s805 0 0 nch W=0.5u L=0.18u
Mp806 s806 s805 vdd vdd pch W=1u L=0.18u
Mn807 s807 s806 0 0 nch W=0.5u L=0.18u
Mp807 s807 s806 vdd vdd pch W=1u L=0.18u
Mn808 s808 s807 0 0 nch W=0.5u L=0.18u
Mp808 s808 s807 vdd vdd pch W=1u L=0.18u
Mn809 s809 s808 0 0 nch W=0.5u L=0.18u
Mp809 s809 s808 vdd vdd pch W=1u L=0.18u
Mn810 s810 s809 0 0 nch W=0.5u L=0.18u
Mp810 s810 s809 vdd vdd pch W=1u L=0.18u
Mn811 s811 s810 0 0 nch W=0.5u L=0.18u
Mp811 s811 s810 vdd vdd pch W=1u L=0.18u
Mn812 s812 s811 0 0 nch W=0.5u L=0.18u
Mp812 s812 s811 vdd vdd pch W=1u L=0.18u
Mn813 s813 s812 0 0 nch W=0.5u L=0.18u
Mp813 s813 s812 vdd vdd pch W=1u L=0.18u
Mn814 s814 s813 0 0 nch W=0.5u L=0.18u
Mp814 s814 s813 vdd vdd pch W=1u L=0.18u
Mn815 s815 s814 0 0 nch W=0.5u L=0.18u
Mp815 s815 s814 vdd vdd pch W=1u L=0.18u
Mn816 s816 s815 0 0 nch W=0.5u L=0.18u
Mp816 s816 s815 vdd vdd pch W=1u L=0.18u
Mn817 s817 s816 0 0 nch W=0.5u L=0.18u
Mp817 s817 s816 vdd vdd pch W=1u L=0.18u
Mn818 s818 s817 0 0 nch W=0.5u L=0.18u
Mp818 s818 s817 vdd vdd pch W=1u L=0.18u
Mn819 s819 s818 0 0 nch W=0.5u L=0.18u
Mp819 s819 s818 vdd vdd pch W=1u L=0.18u
Mn820 s820 s819 0 0 nch W=0.5u L=0.18u
Mp820 s820 s819 vdd vdd pch W=1u L=0.18u
Mn821 s821 s820 0 0 nch W=0.5u L=0.18u
Mp821 s821 s820 vdd vdd pch W=1u L=0.18u
Mn822 s822 s821 0 0 nch W=0.5u L=0.18u
Mp822 s822 s821 vdd vdd pch W=1u L=0.18u
Mn823 s823 s822 0 0 nch W=0.5u L=0.18u
Mp823 s823 s822 vdd vdd pch W=1u L=0.18u
Mn824 s824 s823 0 0 nch W=0.5u L=0.18u
Mp824 s824 s823 vdd vdd pch W=1u L=0.18u
Mn825 s825 s824 0 0 nch W=0.5u L=0.18u
Mp825 s825 s824 vdd vdd pch W=1u L=0.18u
Mn826 s826 s825 0 0 nch W=0.5u L=0.18u
Mp826 s826 s825 vdd vdd pch W=1u L=0.18u
Mn827 s827 s826 0 0 nch W=0.5u L=0.18u
Mp827 s827 s826 vdd vdd pch W=1u L=0.18u
Mn828 s828 s827 0 0 nch W=0.5u L=0.18u
Mp828 s828 s827 vdd vdd pch W=1u L=0.18u
Mn829 s829 s828 0 0 nch W=0.5u L=0.18u
Mp829 s829 s828 vdd vdd pch W=1u L=0.18u
Mn830 s830 s829 0 0 nch W=0.5u L=0.18u
Mp830 s830 s829 vdd vdd pch W=1u L=0.18u
Mn831 s831 s830 0 0 nch W=0.5u L=0.18u
Mp831 s831 s830 vdd vdd pch W=1u L=0.18u
Mn832 s832 s831 0 0 nch W=0.5u L=0.18u
Mp832 s832 s831 vdd vdd pch W=1u L=0.18u
Mn833 s833 s832 0 0 nch W=0.5u L=0.18u
Mp833 s833 s832 vdd vdd pch W=1u L=0.18u
Mn834 s834 s833 0 0 nch W=0.5u L=0.18u
Mp834 s834 s833 vdd vdd pch W=1u L=0.18u
Mn835 s835 s834 0 0 nch W=0.5u L=0.18u
Mp835 s835 s834 vdd vdd pch W=1u L=0.18u
Mn836 s836 s835 0 0 nch W=0.5u L=0.18u
Mp836 s836 s835 vdd vdd pch W=1u L=0.18u
Mn837 s837 s836 0 0 nch W=0.5u L=0.18u
Mp837 s837 s836 vdd vdd pch W=1u L=0.18u
Mn838 s838 s837 0 0 nch W=0.5u L=0.18u
Mp838 s838 s837 vdd vdd pch W=1u L=0.18u
Mn839 s839 s838 0 0 nch W=0.5u L=0.18u
Mp839 s839 s838 vdd vdd pch W=1u L=0.18u
Mn840 s840 s839 0 0 nch W=0.5u L=0.18u
Mp840 s840 s839 vdd vdd pch W=1u L=0.18u
Mn841 s841 s840 0 0 nch W=0.5u L=0.18u
Mp841 s841 s840 vdd vdd pch W=1u L=0.18u
Mn842 s842 s841 0 0 nch W=0.5u L=0.18u
Mp842 s842 s841 vdd vdd pch W=1u L=0.18u
Mn843 s843 s842 0 0 nch W=0.5u L=0.18u
Mp843 s843 s842 vdd vdd pch W=1u L=0.18u
Mn844 s844 s843 0 0 nch W=0.5u L=0.18u
Mp844 s844 s843 vdd vdd pch W=1u L=0.18u
Mn845 s845 s844 0 0 nch W=0.5u L=0.18u
Mp845 s845 s844 vdd vdd pch W=1u L=0.18u
Mn846 s846 s845 0 0 nch W=0.5u L=0.18u
Mp846 s846 s845 vdd vdd pch W=1u L=0.18u
Mn847 s847 s846 0 0 nch W=0.5u L=0.18u
Mp847 s847 s846 vdd vdd pch W=1u L=0.18u
Mn848 s848 s847 0 0 nch W=0.5u L=0.18u
Mp848 s848 s847 vdd vdd pch W=1u L=0.18u
Mn849 s849 s848 0 0 nch W=0.5u L=0.18u
Mp849 s849 s848 vdd vdd pch W=1u L=0.18u
Mn850 s850 s849 0 0 nch W=0.5u L=0.18u
Mp850 s850 s849 vdd vdd pch W=1u L=0.18u
Mn851 s851 s850 0 0 nch W=0.5u L=0.18u
Mp851 s851 s850 vdd vdd pch W=1u L=0.18u
Mn852 s852 s851 0 0 nch W=0.5u L=0.18u
Mp852 s852 s851 vdd vdd pch W=1u L=0.18u
Mn853 s853 s852 0 0 nch W=0.5u L=0.18u
Mp853 s853 s852 vdd vdd pch W=1u L=0.18u
Mn854 s854 s853 0 0 nch W=0.5u L=0.18u
Mp854 s854 s853 vdd vdd pch W=1u L=0.18u
Mn855 s855 s854 0 0 nch W=0.5u L=0.18u
Mp855 s855 s854 vdd vdd pch W=1u L=0.18u
Mn856 s856 s855 0 0 nch W=0.5u L=0.18u
Mp856 s856 s855 vdd vdd pch W=1u L=0.18u
Mn857 s857 s856 0 0 nch W=0.5u L=0.18u
Mp857 s857 s856 vdd vdd pch W=1u L=0.18u
Mn858 s858 s857 0 0 nch W=0.5u L=0.18u
Mp858 s858 s857 vdd vdd pch W=1u L=0.18u
Mn859 s859 s858 0 0 nch W=0.5u L=0.18u
Mp859 s859 s858 vdd vdd pch W=1u L=0.18u
Mn860 s860 s859 0 0 nch W=0.5u L=0.18u
Mp860 s860 s859 vdd vdd pch W=1u L=0.18u
Mn861 s861 s860 0 0 nch W=0.5u L=0.18u
Mp861 s861 s860 vdd vdd pch W=1u L=0.18u
Mn862 s862 s861 0 0 nch W=0.5u L=0.18u
Mp862 s862 s861 vdd vdd pch W=1u L=0.18u
Mn863 s863 s862 0 0 nch W=0.5u L=0.18u
Mp863 s863 s862 vdd vdd pch W=1u L=0.18u
Mn864 s864 s863 0 0 nch W=0.5u L=0.18u
Mp864 s864 s863 vdd vdd pch W=1u L=0.18u
Mn865 s865 s864 0 0 nch W=0.5u L=0.18u
Mp865 s865 s864 vdd vdd pch W=1u L=0.18u
Mn866 s866 s865 0 0 nch W=0.5u L=0.18u
Mp866 s866 s865 vdd vdd pch W=1u L=0.18u
Mn867 s867 s866 0 0 nch W=0.5u L=0.18u
Mp867 s867 s866 vdd vdd pch W=1u L=0.18u
Mn868 s868 s867 0 0 nch W=0.5u L=0.18u
Mp868 s868 s867 vdd vdd pch W=1u L=0.18u
Mn869 s869 s868 0 0 nch W=0.5u L=0.18u
Mp869 s869 s868 vdd vdd pch W=1u L=0.18u
Mn870 s870 s869 0 0 nch W=0.5u L=0.18u
Mp870 s870 s869 vdd vdd pch W=1u L=0.18u
Mn871 s871 s870 0 0 nch W=0.5u L=0.18u
Mp871 s871 s870 vdd vdd pch W=1u L=0.18u
Mn872 s872 s871 0 0 nch W=0.5u L=0.18u
Mp872 s872 s871 vdd vdd pch W=1u L=0.18u
Mn873 s873 s872 0 0 nch W=0.5u L=0.18u
Mp873 s873 s872 vdd vdd pch W=1u L=0.18u
Mn874 s874 s873 0 0 nch W=0.5u L=0.18u
Mp874 s874 s873 vdd vdd pch W=1u L=0.18u
Mn875 s875 s874 0 0 nch W=0.5u L=0.18u
Mp875 s875 s874 vdd vdd pch W=1u L=0.18u
Mn876 s876 s875 0 0 nch W=0.5u L=0.18u
Mp876 s876 s875 vdd vdd pch W=1u L=0.18u
Mn877 s877 s876 0 0 nch W=0.5u L=0.18u
Mp877 s877 s876 vdd vdd pch W=1u L=0.18u
Mn878 s878 s877 0 0 nch W=0.5u L=0.18u
Mp878 s878 s877 vdd vdd pch W=1u L=0.18u
Mn879 s879 s878 0 0 nch W=0.5u L=0.18u
Mp879 s879 s878 vdd vdd pch W=1u L=0.18u
Mn880 s880 s879 0 0 nch W=0.5u L=0.18u
Mp880 s880 s879 vdd vdd pch W=1u L=0.18u
Mn881 s881 s880 0 0 nch W=0.5u L=0.18u
Mp881 s881 s880 vdd vdd pch W=1u L=0.18u
Mn882 s882 s881 0 0 nch W=0.5u L=0.18u
Mp882 s882 s881 vdd vdd pch W=1u L=0.18u
Mn883 s883 s882 0 0 nch W=0.5u L=0.18u
Mp883 s883 s882 vdd vdd pch W=1u L=0.18u
Mn884 s884 s883 0 0 nch W=0.5u L=0.18u
Mp884 s884 s883 vdd vdd pch W=1u L=0.18u
Mn885 s885 s884 0 0 nch W=0.5u L=0.18u
Mp885 s885 s884 vdd vdd pch W=1u L=0.18u
Mn886 s886 s885 0 0 nch W=0.5u L=0.18u
Mp886 s886 s885 vdd vdd pch W=1u L=0.18u
Mn887 s887 s886 0 0 nch W=0.5u L=0.18u
Mp887 s887 s886 vdd vdd pch W=1u L=0.18u
Mn888 s888 s887 0 0 nch W=0.5u L=0.18u
Mp888 s888 s887 vdd vdd pch W=1u L=0.18u
Mn889 s889 s888 0 0 nch W=0.5u L=0.18u
Mp889 s889 s888 vdd vdd pch W=1u L=0.18u
Mn890 s890 s889 0 0 nch W=0.5u L=0.18u
Mp890 s890 s889 vdd vdd pch W=1u L=0.18u
Mn891 s891 s890 0 0 nch W=0.5u L=0.18u
Mp891 s891 s890 vdd vdd pch W=1u L=0.18u
Mn892 s892 s891 0 0 nch W=0.5u L=0.18u
Mp892 s892 s891 vdd vdd pch W=1u L=0.18u
Mn893 s893 s892 0 0 nch W=0.5u L=0.18u
Mp893 s893 s892 vdd vdd pch W=1u L=0.18u
Mn894 s894 s893 0 0 nch W=0.5u L=0.18u
Mp894 s894 s893 vdd vdd pch W=1u L=0.18u
Mn895 s895 s894 0 0 nch W=0.5u L=0.18u
Mp895 s895 s894 vdd vdd pch W=1u L=0.18u
Mn896 s896 s895 0 0 nch W=0.5u L=0.18u
Mp896 s896 s895 vdd vdd pch W=1u L=0.18u
Mn897 s897 s896 0 0 nch W=0.5u L=0.18u
Mp897 s897 s896 vdd vdd pch W=1u L=0.18u
Mn898 s898 s897 0 0 nch W=0.5u L=0.18u
Mp898 s898 s897 vdd vdd pch W=1u L=0.18u
Mn899 s899 s898 0 0 nch W=0.5u L=0.18u
Mp899 s899 s898 vdd vdd pch W=1u L=0.18u
Mn900 s900 s899 0 0 nch W=0.5u L=0.18u
Mp900 s900 s899 vdd vdd pch W=1u L=0.18u
Mn901 s901 s900 0 0 nch W=0.5u L=0.18u
Mp901 s901 s900 vdd vdd pch W=1u L=0.18u
Mn902 s902 s901 0 0 nch W=0.5u L=0.18u
Mp902 s902 s901 vdd vdd pch W=1u L=0.18u
Mn903 s903 s902 0 0 nch W=0.5u L=0.18u
Mp903 s903 s902 vdd vdd pch W=1u L=0.18u
Mn904 s904 s903 0 0 nch W=0.5u L=0.18u
Mp904 s904 s903 vdd vdd pch W=1u L=0.18u
Mn905 s905 s904 0 0 nch W=0.5u L=0.18u
Mp905 s905 s904 vdd vdd pch W=1u L=0.18u
Mn906 s906 s905 0 0 nch W=0.5u L=0.18u
Mp906 s906 s905 vdd vdd pch W=1u L=0.18u
Mn907 s907 s906 0 0 nch W=0.5u L=0.18u
Mp907 s907 s906 vdd vdd pch W=1u L=0.18u
Mn908 s908 s907 0 0 nch W=0.5u L=0.18u
Mp908 s908 s907 vdd vdd pch W=1u L=0.18u
Mn909 s909 s908 0 0 nch W=0.5u L=0.18u
Mp909 s909 s908 vdd vdd pch W=1u L=0.18u
Mn910 s910 s909 0 0 nch W=0.5u L=0.18u
Mp910 s910 s909 vdd vdd pch W=1u L=0.18u
Mn911 s911 s910 0 0 nch W=0.5u L=0.18u
Mp911 s911 s910 vdd vdd pch W=1u L=0.18u
Mn912 s912 s911 0 0 nch W=0.5u L=0.18u
Mp912 s912 s911 vdd vdd pch W=1u L=0.18u
Mn913 s913 s912 0 0 nch W=0.5u L=0.18u
Mp913 s913 s912 vdd vdd pch W=1u L=0.18u
Mn914 s914 s913 0 0 nch W=0.5u L=0.18u
Mp914 s914 s913 vdd vdd pch W=1u L=0.18u
Mn915 s915 s914 0 0 nch W=0.5u L=0.18u
Mp915 s915 s914 vdd vdd pch W=1u L=0.18u
Mn916 s916 s915 0 0 nch W=0.5u L=0.18u
Mp916 s916 s915 vdd vdd pch W=1u L=0.18u
Mn917 s917 s916 0 0 nch W=0.5u L=0.18u
Mp917 s917 s916 vdd vdd pch W=1u L=0.18u
Mn918 s918 s917 0 0 nch W=0.5u L=0.18u
Mp918 s918 s917 vdd vdd pch W=1u L=0.18u
Mn919 s919 s918 0 0 nch W=0.5u L=0.18u
Mp919 s919 s918 vdd vdd pch W=1u L=0.18u
Mn920 s920 s919 0 0 nch W=0.5u L=0.18u
Mp920 s920 s919 vdd vdd pch W=1u L=0.18u
Mn921 s921 s920 0 0 nch W=0.5u L=0.18u
Mp921 s921 s920 vdd vdd pch W=1u L=0.18u
Mn922 s922 s921 0 0 nch W=0.5u L=0.18u
Mp922 s922 s921 vdd vdd pch W=1u L=0.18u
Mn923 s923 s922 0 0 nch W=0.5u L=0.18u
Mp923 s923 s922 vdd vdd pch W=1u L=0.18u
Mn924 s924 s923 0 0 nch W=0.5u L=0.18u
Mp924 s924 s923 vdd vdd pch W=1u L=0.18u
Mn925 s925 s924 0 0 nch W=0.5u L=0.18u
Mp925 s925 s924 vdd vdd pch W=1u L=0.18u
Mn926 s926 s925 0 0 nch W=0.5u L=0.18u
Mp926 s926 s925 vdd vdd pch W=1u L=0.18u
Mn927 s927 s926 0 0 nch W=0.5u L=0.18u
Mp927 s927 s926 vdd vdd pch W=1u L=0.18u
Mn928 s928 s927 0 0 nch W=0.5u L=0.18u
Mp928 s928 s927 vdd vdd pch W=1u L=0.18u
Mn929 s929 s928 0 0 nch W=0.5u L=0.18u
Mp929 s929 s928 vdd vdd pch W=1u L=0.18u
Mn930 s930 s929 0 0 nch W=0.5u L=0.18u
Mp930 s930 s929 vdd vdd pch W=1u L=0.18u
Mn931 s931 s930 0 0 nch W=0.5u L=0.18u
Mp931 s931 s930 vdd vdd pch W=1u L=0.18u
Mn932 s932 s931 0 0 nch W=0.5u L=0.18u
Mp932 s932 s931 vdd vdd pch W=1u L=0.18u
Mn933 s933 s932 0 0 nch W=0.5u L=0.18u
Mp933 s933 s932 vdd vdd pch W=1u L=0.18u
Mn934 s934 s933 0 0 nch W=0.5u L=0.18u
Mp934 s934 s933 vdd vdd pch W=1u L=0.18u
Mn935 s935 s934 0 0 nch W=0.5u L=0.18u
Mp935 s935 s934 vdd vdd pch W=1u L=0.18u
Mn936 s936 s935 0 0 nch W=0.5u L=0.18u
Mp936 s936 s935 vdd vdd pch W=1u L=0.18u
Mn937 s937 s936 0 0 nch W=0.5u L=0.18u
Mp937 s937 s936 vdd vdd pch W=1u L=0.18u
Mn938 s938 s937 0 0 nch W=0.5u L=0.18u
Mp938 s938 s937 vdd vdd pch W=1u L=0.18u
Mn939 s939 s938 0 0 nch W=0.5u L=0.18u
Mp939 s939 s938 vdd vdd pch W=1u L=0.18u
Mn940 s940 s939 0 0 nch W=0.5u L=0.18u
Mp940 s940 s939 vdd vdd pch W=1u L=0.18u
Mn941 s941 s940 0 0 nch W=0.5u L=0.18u
Mp941 s941 s940 vdd vdd pch W=1u L=0.18u
Mn942 s942 s941 0 0 nch W=0.5u L=0.18u
Mp942 s942 s941 vdd vdd pch W=1u L=0.18u
Mn943 s943 s942 0 0 nch W=0.5u L=0.18u
Mp943 s943 s942 vdd vdd pch W=1u L=0.18u
Mn944 s944 s943 0 0 nch W=0.5u L=0.18u
Mp944 s944 s943 vdd vdd pch W=1u L=0.18u
Mn945 s945 s944 0 0 nch W=0.5u L=0.18u
Mp945 s945 s944 vdd vdd pch W=1u L=0.18u
Mn946 s946 s945 0 0 nch W=0.5u L=0.18u
Mp946 s946 s945 vdd vdd pch W=1u L=0.18u
Mn947 s947 s946 0 0 nch W=0.5u L=0.18u
Mp947 s947 s946 vdd vdd pch W=1u L=0.18u
Mn948 s948 s947 0 0 nch W=0.5u L=0.18u
Mp948 s948 s947 vdd vdd pch W=1u L=0.18u
Mn949 s949 s948 0 0 nch W=0.5u L=0.18u
Mp949 s949 s948 vdd vdd pch W=1u L=0.18u
Mn950 s950 s949 0 0 nch W=0.5u L=0.18u
Mp950 s950 s949 vdd vdd pch W=1u L=0.18u
Mn951 s951 s950 0 0 nch W=0.5u L=0.18u
Mp951 s951 s950 vdd vdd pch W=1u L=0.18u
Mn952 s952 s951 0 0 nch W=0.5u L=0.18u
Mp952 s952 s951 vdd vdd pch W=1u L=0.18u
Mn953 s953 s952 0 0 nch W=0.5u L=0.18u
Mp953 s953 s952 vdd vdd pch W=1u L=0.18u
Mn954 s954 s953 0 0 nch W=0.5u L=0.18u
Mp954 s954 s953 vdd vdd pch W=1u L=0.18u
Mn955 s955 s954 0 0 nch W=0.5u L=0.18u
Mp955 s955 s954 vdd vdd pch W=1u L=0.18u
Mn956 s956 s955 0 0 nch W=0.5u L=0.18u
Mp956 s956 s955 vdd vdd pch W=1u L=0.18u
Mn957 s957 s956 0 0 nch W=0.5u L=0.18u
Mp957 s957 s956 vdd vdd pch W=1u L=0.18u
Mn958 s958 s957 0 0 nch W=0.5u L=0.18u
Mp958 s958 s957 vdd vdd pch W=1u L=0.18u
Mn959 s959 s958 0 0 nch W=0.5u L=0.18u
Mp959 s959 s958 vdd vdd pch W=1u L=0.18u
Mn960 s960 s959 0 0 nch W=0.5u L=0.18u
Mp960 s960 s959 vdd vdd pch W=1u L=0.18u
Mn961 s961 s960 0 0 nch W=0.5u L=0.18u
Mp961 s961 s960 vdd vdd pch W=1u L=0.18u
Mn962 s962 s961 0 0 nch W=0.5u L=0.18u
Mp962 s962 s961 vdd vdd pch W=1u L=0.18u
Mn963 s963 s962 0 0 nch W=0.5u L=0.18u
Mp963 s963 s962 vdd vdd pch W=1u L=0.18u
Mn964 s964 s963 0 0 nch W=0.5u L=0.18u
Mp964 s964 s963 vdd vdd pch W=1u L=0.18u
Mn965 s965 s964 0 0 nch W=0.5u L=0.18u
Mp965 s965 s964 vdd vdd pch W=1u L=0.18u
Mn966 s966 s965 0 0 nch W=0.5u L=0.18u
Mp966 s966 s965 vdd vdd pch W=1u L=0.18u
Mn967 s967 s966 0 0 nch W=0.5u L=0.18u
Mp967 s967 s966 vdd vdd pch W=1u L=0.18u
Mn968 s968 s967 0 0 nch W=0.5u L=0.18u
Mp968 s968 s967 vdd vdd pch W=1u L=0.18u
Mn969 s969 s968 0 0 nch W=0.5u L=0.18u
Mp969 s969 s968 vdd vdd pch W=1u L=0.18u
Mn970 s970 s969 0 0 nch W=0.5u L=0.18u
Mp970 s970 s969 vdd vdd pch W=1u L=0.18u
Mn971 s971 s970 0 0 nch W=0.5u L=0.18u
Mp971 s971 s970 vdd vdd pch W=1u L=0.18u
Mn972 s972 s971 0 0 nch W=0.5u L=0.18u
Mp972 s972 s971 vdd vdd pch W=1u L=0.18u
Mn973 s973 s972 0 0 nch W=0.5u L=0.18u
Mp973 s973 s972 vdd vdd pch W=1u L=0.18u
Mn974 s974 s973 0 0 nch W=0.5u L=0.18u
Mp974 s974 s973 vdd vdd pch W=1u L=0.18u
Mn975 s975 s974 0 0 nch W=0.5u L=0.18u
Mp975 s975 s974 vdd vdd pch W=1u L=0.18u
Mn976 s976 s975 0 0 nch W=0.5u L=0.18u
Mp976 s976 s975 vdd vdd pch W=1u L=0.18u
Mn977 s977 s976 0 0 nch W=0.5u L=0.18u
Mp977 s977 s976 vdd vdd pch W=1u L=0.18u
Mn978 s978 s977 0 0 nch W=0.5u L=0.18u
Mp978 s978 s977 vdd vdd pch W=1u L=0.18u
Mn979 s979 s978 0 0 nch W=0.5u L=0.18u
Mp979 s979 s978 vdd vdd pch W=1u L=0.18u
Mn980 s980 s979 0 0 nch W=0.5u L=0.18u
Mp980 s980 s979 vdd vdd pch W=1u L=0.18u
Mn981 s981 s980 0 0 nch W=0.5u L=0.18u
Mp981 s981 s980 vdd vdd pch W=1u L=0.18u
Mn982 s982 s981 0 0 nch W=0.5u L=0.18u
Mp982 s982 s981 vdd vdd pch W=1u L=0.18u
Mn983 s983 s982 0 0 nch W=0.5u L=0.18u
Mp983 s983 s982 vdd vdd pch W=1u L=0.18u
Mn984 s984 s983 0 0 nch W=0.5u L=0.18u
Mp984 s984 s983 vdd vdd pch W=1u L=0.18u
Mn985 s985 s984 0 0 nch W=0.5u L=0.18u
Mp985 s985 s984 vdd vdd pch W=1u L=0.18u
Mn986 s986 s985 0 0 nch W=0.5u L=0.18u
Mp986 s986 s985 vdd vdd pch W=1u L=0.18u
Mn987 s987 s986 0 0 nch W=0.5u L=0.18u
Mp987 s987 s986 vdd vdd pch W=1u L=0.18u
Mn988 s988 s987 0 0 nch W=0.5u L=0.18u
Mp988 s988 s987 vdd vdd pch W=1u L=0.18u
Mn989 s989 s988 0 0 nch W=0.5u L=0.18u
Mp989 s989 s988 vdd vdd pch W=1u L=0.18u
Mn990 s990 s989 0 0 nch W=0.5u L=0.18u
Mp990 s990 s989 vdd vdd pch W=1u L=0.18u
Mn991 s991 s990 0 0 nch W=0.5u L=0.18u
Mp991 s991 s990 vdd vdd pch W=1u L=0.18u
Mn992 s992 s991 0 0 nch W=0.5u L=0.18u
Mp992 s992 s991 vdd vdd pch W=1u L=0.18u
Mn993 s993 s992 0 0 nch W=0.5u L=0.18u
Mp993 s993 s992 vdd vdd pch W=1u L=0.18u
Mn994 s994 s993 0 0 nch W=0.5u L=0.18u
Mp994 s994 s993 vdd vdd pch W=1u L=0.18u
Mn995 s995 s994 0 0 nch W=0.5u L=0.18u
Mp995 s995 s994 vdd vdd pch W=1u L=0.18u
Mn996 s996 s995 0 0 nch W=0.5u L=0.18u
Mp996 s996 s995 vdd vdd pch W=1u L=0.18u
Mn997 s997 s996 0 0 nch W=0.5u L=0.18u
Mp997 s997 s996 vdd vdd pch W=1u L=0.18u
Mn998 s998 s997 0 0 nch W=0.5u L=0.18u
Mp998 s998 s997 vdd vdd pch W=1u L=0.18u
Mn999 s999 s998 0 0 nch W=0.5u L=0.18u
Mp999 s999 s998 vdd vdd pch W=1u L=0.18u
Mn1000 s1000 s999 0 0 nch W=0.5u L=0.18u
Mp1000 s1000 s999 vdd vdd pch W=1u L=0.18u
Cload s1000 0 10f
.tran 0.1n 50n
.end
