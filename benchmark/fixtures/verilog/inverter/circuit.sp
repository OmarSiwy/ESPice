* Verilog inverter: input high -> output driven low
.hdl "v_inv.v"
Vin a 0 DC 5
Rl y 0 10k
N1 a y v_inv
.op
.end
