* Topology fixture: two unequal voltage sources in a direct loop.
* Golden = the engine's named voltage-loop (inconsistent KVL cycle) error.
V1 a 0 DC 5
V2 a 0 DC 3
R1 a 0 1k
.op
.end
