* Topology fixture: two unequal current sources in series through node
* `mid` with no other connection. Golden = the engine's named cutset error.
I1 0 mid DC 1m
I2 mid 0 DC 2m
.op
.end
