* Verilog-A diode clamp: va_diode under 1k -> v(out) ~ 0.57 V
Vin in 0 DC 5
R1 in out 1k
N1 out 0 va_diode
.op
.end
