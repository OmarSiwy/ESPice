* Verilog-A resistor divider: baked va_res (100 ohm) under R1 -> v(out) = 0.35
N1 out 0 va_res
R1 in out 100
Vin in 0 DC 0.7
.op
.end
