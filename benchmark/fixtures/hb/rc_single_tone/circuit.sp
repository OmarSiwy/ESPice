* HB bench fixture: single-tone RC low-pass (linear -> one HB iteration).
Vin in 0 DC 0 AC 1 SIN(0 1 1k)
R1 in out 1k
C1 out 0 1u
.hb 1k
.end
