* PSS bench fixture: sine-driven RC, shooting lands on the periodic state.
Vin in 0 DC 0 SIN(0 2 1k)
R1 in out 1k
C1 out 0 1u
.pss 1k 2m v(out) 256 4 50 1m
.end
