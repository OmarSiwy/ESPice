* Unit fixture: independent voltage source — PULSE waveform into a load.
V1 in 0 DC 0 PULSE(0 5 1u 1u 1u 5u 12u)
R1 in 0 1k
.tran 0.1u 30u
.end
