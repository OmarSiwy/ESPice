* Inductor AC impedance: verifies jwL frequency response.
V1 in 0 DC 0 AC 1
R1 in mid 1k
L1 mid 0 1m
.ac dec 20 1 10meg
.end
