* Unit fixture: E source (VCVS), gain 2 on a divider tap.
Vin in 0 DC 3
R1 in mid 1k
R2 mid 0 2k
E1 out 0 mid 0 2
RL out 0 10k
.op
.end
