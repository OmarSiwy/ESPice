* Unit fixture: G source (VCCS) driving a load from a divider voltage.
Vin in 0 DC 4
R1 in mid 1k
R2 mid 0 1k
G1 0 out mid 0 1m
RL out 0 2k
.op
.end
