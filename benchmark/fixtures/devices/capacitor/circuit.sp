* RC charging: capacitor exercised in transient analysis.
V1 in 0 DC 5
R1 in n1 1k
C1 n1 0 1u
.tran 10u 5m
.end
