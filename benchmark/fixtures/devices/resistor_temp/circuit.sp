* Resistor temperature sweep: tests TC1, TC2 coefficients.
V1 a 0 DC 5
R1 a 0 1k TC=3.9e-3,5.6e-7
.dc TEMP -40 125 5
.end
