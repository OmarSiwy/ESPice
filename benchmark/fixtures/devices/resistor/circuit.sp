* Single resistor across a DC source: I = V/R, basic Ohm's law.
V1 a 0 DC 10
R1 a 0 2k
.op
.end
