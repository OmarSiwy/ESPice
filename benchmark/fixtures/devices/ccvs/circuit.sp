* Unit fixture: H source (CCVS) sensing an ammeter current.
Vin in 0 DC 2
R1 in sense 1k
Vam sense 0 DC 0
H1 out 0 Vam 500
RL out 0 1k
.op
.end
