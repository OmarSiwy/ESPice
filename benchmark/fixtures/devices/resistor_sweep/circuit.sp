* Resistor I-V linearity check: sweep voltage, verify Ohm's law.
V1 a 0 DC 0
R1 a 0 2k
.dc V1 -10 10 0.1
.end
