* Unit fixture: F source (CCCS) mirroring an ammeter current.
Vin in 0 DC 5
R1 in sense 1k
Vam sense 0 DC 0
F1 0 out Vam 2
RL out 0 500
.op
.end
