* Unit fixture: independent current source into a resistive divider.
I1 0 out DC 1m
R1 out 0 1k
R2 out 0 1k
.op
.end
