Synthetic RC fanout with coupling and nonuniform loads
Vin in 0 PULSE(0 1 1n 10p 10p 5n 10n)
R0 in out0 1000
C0 out0 0 1p
R1 in out1 1010
C1 out1 0 1p
Cc1 out0 out1 20f
R2 in out2 1020
C2 out2 0 1p
Cc2 out1 out2 20f
R3 in out3 1030
C3 out3 0 1p
Cc3 out2 out3 20f
R4 in out4 1040
C4 out4 0 1p
Cc4 out3 out4 20f
R5 in out5 1050
C5 out5 0 1p
Cc5 out4 out5 20f
R6 in out6 1060
C6 out6 0 1p
Cc6 out5 out6 20f
R7 in out7 1070
C7 out7 0 1p
Cc7 out6 out7 20f
R8 in out8 1080
C8 out8 0 1p
Cc8 out7 out8 20f
R9 in out9 1090
C9 out9 0 1p
Cc9 out8 out9 20f
R10 in out10 1100
C10 out10 0 1p
Cc10 out9 out10 20f
R11 in out11 1110
C11 out11 0 1p
Cc11 out10 out11 20f
R12 in out12 1120
C12 out12 0 1p
Cc12 out11 out12 20f
R13 in out13 1130
C13 out13 0 1p
Cc13 out12 out13 20f
R14 in out14 1140
C14 out14 0 1p
Cc14 out13 out14 20f
R15 in out15 1150
C15 out15 0 1p
Cc15 out14 out15 20f
R16 in out16 1160
C16 out16 0 1p
Cc16 out15 out16 20f
R17 in out17 1170
C17 out17 0 1p
Cc17 out16 out17 20f
R18 in out18 1180
C18 out18 0 1p
Cc18 out17 out18 20f
R19 in out19 1190
C19 out19 0 1p
Cc19 out18 out19 20f
R20 in out20 1200
C20 out20 0 1p
Cc20 out19 out20 20f
R21 in out21 1210
C21 out21 0 1p
Cc21 out20 out21 20f
R22 in out22 1220
C22 out22 0 1p
Cc22 out21 out22 20f
R23 in out23 1230
C23 out23 0 1p
Cc23 out22 out23 20f
R24 in out24 1240
C24 out24 0 1p
Cc24 out23 out24 20f
R25 in out25 1250
C25 out25 0 1p
Cc25 out24 out25 20f
R26 in out26 1260
C26 out26 0 1p
Cc26 out25 out26 20f
R27 in out27 1270
C27 out27 0 1p
Cc27 out26 out27 20f
R28 in out28 1280
C28 out28 0 1p
Cc28 out27 out28 20f
R29 in out29 1290
C29 out29 0 1p
Cc29 out28 out29 20f
R30 in out30 1300
C30 out30 0 1p
Cc30 out29 out30 20f
R31 in out31 1310
C31 out31 0 1p
Cc31 out30 out31 20f
.tran 1p 10n 0 1p
.end
