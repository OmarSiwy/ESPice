Capacitor-only island: transient OP must initialize charge before time stepping
V1 in 0 DC 1 PULSE(1 2 1n 10p 10p 2n 4n)
R1 in 0 1k
C1 in island 1p
C2 island 0 1p
.tran 1p 2n
.end
