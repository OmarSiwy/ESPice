Synthetic 8x8 interconnect mesh: exact DC row symmetry
* No production extraction; horizontal and vertical 1 kohm segments.
Vin in 0 1
Rh0_0 in n0_0 1k
Cg0_0 n0_0 0 4f
Rh0_1 n0_0 n0_1 1k
Cg0_1 n0_1 0 4f
Rh0_2 n0_1 n0_2 1k
Cg0_2 n0_2 0 4f
Rh0_3 n0_2 n0_3 1k
Cg0_3 n0_3 0 4f
Rh0_4 n0_3 n0_4 1k
Cg0_4 n0_4 0 4f
Rh0_5 n0_4 n0_5 1k
Cg0_5 n0_5 0 4f
Rh0_6 n0_5 n0_6 1k
Cg0_6 n0_6 0 4f
Rh0_7 n0_6 n0_7 1k
Cg0_7 n0_7 0 4f
Rt0 n0_7 0 1k
Rh1_0 in n1_0 1k
Cg1_0 n1_0 0 4f
Rv1_0 n0_0 n1_0 1k
Rh1_1 n1_0 n1_1 1k
Cg1_1 n1_1 0 4f
Rv1_1 n0_1 n1_1 1k
Rh1_2 n1_1 n1_2 1k
Cg1_2 n1_2 0 4f
Rv1_2 n0_2 n1_2 1k
Rh1_3 n1_2 n1_3 1k
Cg1_3 n1_3 0 4f
Rv1_3 n0_3 n1_3 1k
Rh1_4 n1_3 n1_4 1k
Cg1_4 n1_4 0 4f
Rv1_4 n0_4 n1_4 1k
Rh1_5 n1_4 n1_5 1k
Cg1_5 n1_5 0 4f
Rv1_5 n0_5 n1_5 1k
Rh1_6 n1_5 n1_6 1k
Cg1_6 n1_6 0 4f
Rv1_6 n0_6 n1_6 1k
Rh1_7 n1_6 n1_7 1k
Cg1_7 n1_7 0 4f
Rv1_7 n0_7 n1_7 1k
Rt1 n1_7 0 1k
Rh2_0 in n2_0 1k
Cg2_0 n2_0 0 4f
Rv2_0 n1_0 n2_0 1k
Rh2_1 n2_0 n2_1 1k
Cg2_1 n2_1 0 4f
Rv2_1 n1_1 n2_1 1k
Rh2_2 n2_1 n2_2 1k
Cg2_2 n2_2 0 4f
Rv2_2 n1_2 n2_2 1k
Rh2_3 n2_2 n2_3 1k
Cg2_3 n2_3 0 4f
Rv2_3 n1_3 n2_3 1k
Rh2_4 n2_3 n2_4 1k
Cg2_4 n2_4 0 4f
Rv2_4 n1_4 n2_4 1k
Rh2_5 n2_4 n2_5 1k
Cg2_5 n2_5 0 4f
Rv2_5 n1_5 n2_5 1k
Rh2_6 n2_5 n2_6 1k
Cg2_6 n2_6 0 4f
Rv2_6 n1_6 n2_6 1k
Rh2_7 n2_6 n2_7 1k
Cg2_7 n2_7 0 4f
Rv2_7 n1_7 n2_7 1k
Rt2 n2_7 0 1k
Rh3_0 in n3_0 1k
Cg3_0 n3_0 0 4f
Rv3_0 n2_0 n3_0 1k
Rh3_1 n3_0 n3_1 1k
Cg3_1 n3_1 0 4f
Rv3_1 n2_1 n3_1 1k
Rh3_2 n3_1 n3_2 1k
Cg3_2 n3_2 0 4f
Rv3_2 n2_2 n3_2 1k
Rh3_3 n3_2 n3_3 1k
Cg3_3 n3_3 0 4f
Rv3_3 n2_3 n3_3 1k
Rh3_4 n3_3 n3_4 1k
Cg3_4 n3_4 0 4f
Rv3_4 n2_4 n3_4 1k
Rh3_5 n3_4 n3_5 1k
Cg3_5 n3_5 0 4f
Rv3_5 n2_5 n3_5 1k
Rh3_6 n3_5 n3_6 1k
Cg3_6 n3_6 0 4f
Rv3_6 n2_6 n3_6 1k
Rh3_7 n3_6 n3_7 1k
Cg3_7 n3_7 0 4f
Rv3_7 n2_7 n3_7 1k
Rt3 n3_7 0 1k
Rh4_0 in n4_0 1k
Cg4_0 n4_0 0 4f
Rv4_0 n3_0 n4_0 1k
Rh4_1 n4_0 n4_1 1k
Cg4_1 n4_1 0 4f
Rv4_1 n3_1 n4_1 1k
Rh4_2 n4_1 n4_2 1k
Cg4_2 n4_2 0 4f
Rv4_2 n3_2 n4_2 1k
Rh4_3 n4_2 n4_3 1k
Cg4_3 n4_3 0 4f
Rv4_3 n3_3 n4_3 1k
Rh4_4 n4_3 n4_4 1k
Cg4_4 n4_4 0 4f
Rv4_4 n3_4 n4_4 1k
Rh4_5 n4_4 n4_5 1k
Cg4_5 n4_5 0 4f
Rv4_5 n3_5 n4_5 1k
Rh4_6 n4_5 n4_6 1k
Cg4_6 n4_6 0 4f
Rv4_6 n3_6 n4_6 1k
Rh4_7 n4_6 n4_7 1k
Cg4_7 n4_7 0 4f
Rv4_7 n3_7 n4_7 1k
Rt4 n4_7 0 1k
Rh5_0 in n5_0 1k
Cg5_0 n5_0 0 4f
Rv5_0 n4_0 n5_0 1k
Rh5_1 n5_0 n5_1 1k
Cg5_1 n5_1 0 4f
Rv5_1 n4_1 n5_1 1k
Rh5_2 n5_1 n5_2 1k
Cg5_2 n5_2 0 4f
Rv5_2 n4_2 n5_2 1k
Rh5_3 n5_2 n5_3 1k
Cg5_3 n5_3 0 4f
Rv5_3 n4_3 n5_3 1k
Rh5_4 n5_3 n5_4 1k
Cg5_4 n5_4 0 4f
Rv5_4 n4_4 n5_4 1k
Rh5_5 n5_4 n5_5 1k
Cg5_5 n5_5 0 4f
Rv5_5 n4_5 n5_5 1k
Rh5_6 n5_5 n5_6 1k
Cg5_6 n5_6 0 4f
Rv5_6 n4_6 n5_6 1k
Rh5_7 n5_6 n5_7 1k
Cg5_7 n5_7 0 4f
Rv5_7 n4_7 n5_7 1k
Rt5 n5_7 0 1k
Rh6_0 in n6_0 1k
Cg6_0 n6_0 0 4f
Rv6_0 n5_0 n6_0 1k
Rh6_1 n6_0 n6_1 1k
Cg6_1 n6_1 0 4f
Rv6_1 n5_1 n6_1 1k
Rh6_2 n6_1 n6_2 1k
Cg6_2 n6_2 0 4f
Rv6_2 n5_2 n6_2 1k
Rh6_3 n6_2 n6_3 1k
Cg6_3 n6_3 0 4f
Rv6_3 n5_3 n6_3 1k
Rh6_4 n6_3 n6_4 1k
Cg6_4 n6_4 0 4f
Rv6_4 n5_4 n6_4 1k
Rh6_5 n6_4 n6_5 1k
Cg6_5 n6_5 0 4f
Rv6_5 n5_5 n6_5 1k
Rh6_6 n6_5 n6_6 1k
Cg6_6 n6_6 0 4f
Rv6_6 n5_6 n6_6 1k
Rh6_7 n6_6 n6_7 1k
Cg6_7 n6_7 0 4f
Rv6_7 n5_7 n6_7 1k
Rt6 n6_7 0 1k
Rh7_0 in n7_0 1k
Cg7_0 n7_0 0 4f
Rv7_0 n6_0 n7_0 1k
Rh7_1 n7_0 n7_1 1k
Cg7_1 n7_1 0 4f
Rv7_1 n6_1 n7_1 1k
Rh7_2 n7_1 n7_2 1k
Cg7_2 n7_2 0 4f
Rv7_2 n6_2 n7_2 1k
Rh7_3 n7_2 n7_3 1k
Cg7_3 n7_3 0 4f
Rv7_3 n6_3 n7_3 1k
Rh7_4 n7_3 n7_4 1k
Cg7_4 n7_4 0 4f
Rv7_4 n6_4 n7_4 1k
Rh7_5 n7_4 n7_5 1k
Cg7_5 n7_5 0 4f
Rv7_5 n6_5 n7_5 1k
Rh7_6 n7_5 n7_6 1k
Cg7_6 n7_6 0 4f
Rv7_6 n6_6 n7_6 1k
Rh7_7 n7_6 n7_7 1k
Cg7_7 n7_7 0 4f
Rv7_7 n6_7 n7_7 1k
Rt7 n7_7 0 1k
.op
.end
