* SP fixture: resistive pi attenuator (~6 dB at 50 ohm), flat S21.
VP1 in 0 DC 0 AC 1 portnum 1 z0 50
R1 in 0 150
R2 in out 37.5
R3 out 0 150
VP2 out 0 DC 0 portnum 2 z0 50
.sp lin 20 1meg 500meg
.end
