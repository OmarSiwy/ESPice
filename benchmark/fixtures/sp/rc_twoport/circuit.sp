* SP fixture: RC low-pass as a 50-ohm two-port, S-parameters.
VP1 in 0 DC 0 AC 1 portnum 1 z0 50
R1 in out 1k
C1 out 0 100p
VP2 out 0 DC 0 portnum 2 z0 50
.sp dec 10 1meg 1g
.end
