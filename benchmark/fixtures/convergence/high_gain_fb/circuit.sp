* High-gain VCVS in unity feedback: stresses Newton near the virtual ground.
Vin in 0 DC 1
Rin in n 1k
Rf n out 1k
E1 out 0 0 n 1e7
.op
.end
