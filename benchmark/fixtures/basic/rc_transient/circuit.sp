RC transient
V1 1 0 5
R1 1 2 1k
C1 2 0 1n
R2 2 0 1meg
.TRAN 1n 10n
.END
