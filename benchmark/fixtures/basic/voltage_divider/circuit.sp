Voltage divider
V1 1 0 10
R1 1 2 5k
R2 2 0 5k
.OP
.END
