* Ideal delay line into a high impedance: pure transport delay observation.
Vin in 0 DC 0 PULSE(0 2 0 50p 50p 2n 8n)
RS in a 75
T1 a 0 b 0 Z0=75 TD=2n
RL b 0 1meg
.tran 20p 12n
.end
