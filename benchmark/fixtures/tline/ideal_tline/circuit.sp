* Ideal lossless transmission line driven by a step, matched load.
Vin in 0 DC 0 PULSE(0 1 0 10p 10p 5n 10n)
RS in a 50
T1 a 0 b 0 Z0=50 TD=1n
RL b 0 50
.tran 10p 8n
.end
