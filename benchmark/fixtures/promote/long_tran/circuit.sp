* Promote fixture: long transient on a small RC — many steps, one structure.
Vin in 0 DC 0 SIN(0 1 10k)
R1 in out 1k
C1 out 0 10n
.tran 0.2u 5m
.end
