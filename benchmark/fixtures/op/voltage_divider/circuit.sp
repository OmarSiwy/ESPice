* DC operating-point fixture: symmetric voltage divider.
Vin in 0 DC 10
R1 in out 5k
R2 out 0 5k
.op
.end
