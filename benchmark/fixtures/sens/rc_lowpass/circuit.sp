* SENS fixture: DC sensitivity of an RC divider output (C drops out at DC).
Vin in 0 DC 6
R1 in out 2k
R2 out 0 1k
C1 out 0 1u
.sens V(out)
.end
