* SENS bench fixture: voltage divider output sensitivity to primitive parameters.
Vin in 0 DC 10
R1 in out 1k
R2 out 0 3k
.sens V(out)
.end
