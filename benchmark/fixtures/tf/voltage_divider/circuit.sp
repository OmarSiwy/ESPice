* TF bench fixture: voltage divider gain and port resistances.
Vin in 0 DC 10 AC 1
R1 in out 1k
R2 out 0 3k
.tf V(out) Vin
.end
