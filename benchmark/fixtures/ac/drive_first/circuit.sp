* AC fixture: two V cards, AC 1 on the FIRST. Control for drive_second.
V1 a 0 DC 0 AC 1
V2 b 0 DC 0
R1 a 0 1k
R2 b 0 1k
.ac dec 2 1k 10k
.end
