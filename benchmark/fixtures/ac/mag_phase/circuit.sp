* AC fixture: the card's magnitude AND phase reach the excitation.
* AC 3 45 is 3*e^(j*pi/4) = 2.1213 + 2.1213j (phase is DEGREES).
V1 a 0 DC 0 AC 3 45
R1 a 0 1k
.ac dec 2 1k 10k
.end
