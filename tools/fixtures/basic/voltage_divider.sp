* Voltage Divider — V(2) = Vin * R2/(R1+R2) = 5 * 1k/(1k+1k) = 2.5V
V1 1 0 DC 5
R1 1 2 1k
R2 2 0 1k
.OP
.END
