* RC Lowpass Filter — f_3dB = 1/(2*pi*R*C) = 159.15 kHz
V1 in 0 DC 1 AC 1
R1 in out 1k
C1 out 0 1n
.AC DEC 10 1 1G
.END
