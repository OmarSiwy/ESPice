* Three Resistor Chain — V(2)=6V, V(3)=3V for 9V source
V1 1 0 DC 9
R1 1 2 1k
R2 2 3 1k
R3 3 0 1k
.OP
.END
