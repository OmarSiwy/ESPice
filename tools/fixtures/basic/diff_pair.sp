* NMOS Differential Pair
VDD 1 0 DC 3.3
VIN1 2 0 DC 1.65
VIN2 3 0 DC 1.65
ISS 4 0 DC 200u
M1 5 2 4 0 NMOD W=10u L=1u
M2 6 3 4 0 NMOD W=10u L=1u
R1 1 5 10k
R2 1 6 10k
.MODEL NMOD NMOS (VTO=0.5 KP=120u)
.OP
.END
