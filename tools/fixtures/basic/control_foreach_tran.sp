* Control script integration test: RC step response
V1 in 0 PULSE(0 1 1n 1n 1n 100n 200n)
R1 in out 1k
C1 out 0 1n
.tran 1n 200n
.end
