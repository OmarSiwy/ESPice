* RC Transient — v(out) = V0*(1 - exp(-t/RC)), RC = 1k * 1n = 1us
V1 in 0 DC 5
R1 in out 1k
C1 out 0 1n
.TRAN 0.1n 10n
.END
