* M15: Temperature Coefficient Test — Resistor TC sweep from -40C to 125C
V1 in 0 DC 1
R1 in out 1k TC=0.01,0.001
R2 out 0 1k
.OP
.DC TEMP -40 125 5
.END
