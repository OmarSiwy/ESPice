* M11: Simple Pole-Zero Analysis — RC network, single pole at -1/(RC)
V1 in 0 DC 0 AC 1
R1 in out 1k
C1 out 0 1n
.PZ V(out) V1 CUR POL
.PZ V(out) V1 CUR ZER
.END
