* Capacitor Bank — 1000 parallel caps
V1 in 0 PULSE(0 5 0 1n 1n 1u 2u)
RS in bus 10

C1 bus 0 1p
C2 bus 0 1p
C3 bus 0 1p
C4 bus 0 1p
C5 bus 0 1p
C6 bus 0 1p
C7 bus 0 1p
C8 bus 0 1p
C9 bus 0 1p
C10 bus 0 1p
C11 bus 0 1p
C12 bus 0 1p
C13 bus 0 1p
C14 bus 0 1p
C15 bus 0 1p
C16 bus 0 1p
C17 bus 0 1p
C18 bus 0 1p
C19 bus 0 1p
C20 bus 0 1p
C21 bus 0 1p
C22 bus 0 1p
C23 bus 0 1p
C24 bus 0 1p
C25 bus 0 1p
C26 bus 0 1p
C27 bus 0 1p
C28 bus 0 1p
C29 bus 0 1p
C30 bus 0 1p
C31 bus 0 1p
C32 bus 0 1p
C33 bus 0 1p
C34 bus 0 1p
C35 bus 0 1p
C36 bus 0 1p
C37 bus 0 1p
C38 bus 0 1p
C39 bus 0 1p
C40 bus 0 1p
C41 bus 0 1p
C42 bus 0 1p
C43 bus 0 1p
C44 bus 0 1p
C45 bus 0 1p
C46 bus 0 1p
C47 bus 0 1p
C48 bus 0 1p
C49 bus 0 1p
C50 bus 0 1p
C51 bus 0 1p
C52 bus 0 1p
C53 bus 0 1p
C54 bus 0 1p
C55 bus 0 1p
C56 bus 0 1p
C57 bus 0 1p
C58 bus 0 1p
C59 bus 0 1p
C60 bus 0 1p
C61 bus 0 1p
C62 bus 0 1p
C63 bus 0 1p
C64 bus 0 1p
C65 bus 0 1p
C66 bus 0 1p
C67 bus 0 1p
C68 bus 0 1p
C69 bus 0 1p
C70 bus 0 1p
C71 bus 0 1p
C72 bus 0 1p
C73 bus 0 1p
C74 bus 0 1p
C75 bus 0 1p
C76 bus 0 1p
C77 bus 0 1p
C78 bus 0 1p
C79 bus 0 1p
C80 bus 0 1p
C81 bus 0 1p
C82 bus 0 1p
C83 bus 0 1p
C84 bus 0 1p
C85 bus 0 1p
C86 bus 0 1p
C87 bus 0 1p
C88 bus 0 1p
C89 bus 0 1p
C90 bus 0 1p
C91 bus 0 1p
C92 bus 0 1p
C93 bus 0 1p
C94 bus 0 1p
C95 bus 0 1p
C96 bus 0 1p
C97 bus 0 1p
C98 bus 0 1p
C99 bus 0 1p
C100 bus 0 1p
C101 bus 0 1p
C102 bus 0 1p
C103 bus 0 1p
C104 bus 0 1p
C105 bus 0 1p
C106 bus 0 1p
C107 bus 0 1p
C108 bus 0 1p
C109 bus 0 1p
C110 bus 0 1p
C111 bus 0 1p
C112 bus 0 1p
C113 bus 0 1p
C114 bus 0 1p
C115 bus 0 1p
C116 bus 0 1p
C117 bus 0 1p
C118 bus 0 1p
C119 bus 0 1p
C120 bus 0 1p
C121 bus 0 1p
C122 bus 0 1p
C123 bus 0 1p
C124 bus 0 1p
C125 bus 0 1p
C126 bus 0 1p
C127 bus 0 1p
C128 bus 0 1p
C129 bus 0 1p
C130 bus 0 1p
C131 bus 0 1p
C132 bus 0 1p
C133 bus 0 1p
C134 bus 0 1p
C135 bus 0 1p
C136 bus 0 1p
C137 bus 0 1p
C138 bus 0 1p
C139 bus 0 1p
C140 bus 0 1p
C141 bus 0 1p
C142 bus 0 1p
C143 bus 0 1p
C144 bus 0 1p
C145 bus 0 1p
C146 bus 0 1p
C147 bus 0 1p
C148 bus 0 1p
C149 bus 0 1p
C150 bus 0 1p
C151 bus 0 1p
C152 bus 0 1p
C153 bus 0 1p
C154 bus 0 1p
C155 bus 0 1p
C156 bus 0 1p
C157 bus 0 1p
C158 bus 0 1p
C159 bus 0 1p
C160 bus 0 1p
C161 bus 0 1p
C162 bus 0 1p
C163 bus 0 1p
C164 bus 0 1p
C165 bus 0 1p
C166 bus 0 1p
C167 bus 0 1p
C168 bus 0 1p
C169 bus 0 1p
C170 bus 0 1p
C171 bus 0 1p
C172 bus 0 1p
C173 bus 0 1p
C174 bus 0 1p
C175 bus 0 1p
C176 bus 0 1p
C177 bus 0 1p
C178 bus 0 1p
C179 bus 0 1p
C180 bus 0 1p
C181 bus 0 1p
C182 bus 0 1p
C183 bus 0 1p
C184 bus 0 1p
C185 bus 0 1p
C186 bus 0 1p
C187 bus 0 1p
C188 bus 0 1p
C189 bus 0 1p
C190 bus 0 1p
C191 bus 0 1p
C192 bus 0 1p
C193 bus 0 1p
C194 bus 0 1p
C195 bus 0 1p
C196 bus 0 1p
C197 bus 0 1p
C198 bus 0 1p
C199 bus 0 1p
C200 bus 0 1p
C201 bus 0 1p
C202 bus 0 1p
C203 bus 0 1p
C204 bus 0 1p
C205 bus 0 1p
C206 bus 0 1p
C207 bus 0 1p
C208 bus 0 1p
C209 bus 0 1p
C210 bus 0 1p
C211 bus 0 1p
C212 bus 0 1p
C213 bus 0 1p
C214 bus 0 1p
C215 bus 0 1p
C216 bus 0 1p
C217 bus 0 1p
C218 bus 0 1p
C219 bus 0 1p
C220 bus 0 1p
C221 bus 0 1p
C222 bus 0 1p
C223 bus 0 1p
C224 bus 0 1p
C225 bus 0 1p
C226 bus 0 1p
C227 bus 0 1p
C228 bus 0 1p
C229 bus 0 1p
C230 bus 0 1p
C231 bus 0 1p
C232 bus 0 1p
C233 bus 0 1p
C234 bus 0 1p
C235 bus 0 1p
C236 bus 0 1p
C237 bus 0 1p
C238 bus 0 1p
C239 bus 0 1p
C240 bus 0 1p
C241 bus 0 1p
C242 bus 0 1p
C243 bus 0 1p
C244 bus 0 1p
C245 bus 0 1p
C246 bus 0 1p
C247 bus 0 1p
C248 bus 0 1p
C249 bus 0 1p
C250 bus 0 1p
C251 bus 0 1p
C252 bus 0 1p
C253 bus 0 1p
C254 bus 0 1p
C255 bus 0 1p
C256 bus 0 1p
C257 bus 0 1p
C258 bus 0 1p
C259 bus 0 1p
C260 bus 0 1p
C261 bus 0 1p
C262 bus 0 1p
C263 bus 0 1p
C264 bus 0 1p
C265 bus 0 1p
C266 bus 0 1p
C267 bus 0 1p
C268 bus 0 1p
C269 bus 0 1p
C270 bus 0 1p
C271 bus 0 1p
C272 bus 0 1p
C273 bus 0 1p
C274 bus 0 1p
C275 bus 0 1p
C276 bus 0 1p
C277 bus 0 1p
C278 bus 0 1p
C279 bus 0 1p
C280 bus 0 1p
C281 bus 0 1p
C282 bus 0 1p
C283 bus 0 1p
C284 bus 0 1p
C285 bus 0 1p
C286 bus 0 1p
C287 bus 0 1p
C288 bus 0 1p
C289 bus 0 1p
C290 bus 0 1p
C291 bus 0 1p
C292 bus 0 1p
C293 bus 0 1p
C294 bus 0 1p
C295 bus 0 1p
C296 bus 0 1p
C297 bus 0 1p
C298 bus 0 1p
C299 bus 0 1p
C300 bus 0 1p
C301 bus 0 1p
C302 bus 0 1p
C303 bus 0 1p
C304 bus 0 1p
C305 bus 0 1p
C306 bus 0 1p
C307 bus 0 1p
C308 bus 0 1p
C309 bus 0 1p
C310 bus 0 1p
C311 bus 0 1p
C312 bus 0 1p
C313 bus 0 1p
C314 bus 0 1p
C315 bus 0 1p
C316 bus 0 1p
C317 bus 0 1p
C318 bus 0 1p
C319 bus 0 1p
C320 bus 0 1p
C321 bus 0 1p
C322 bus 0 1p
C323 bus 0 1p
C324 bus 0 1p
C325 bus 0 1p
C326 bus 0 1p
C327 bus 0 1p
C328 bus 0 1p
C329 bus 0 1p
C330 bus 0 1p
C331 bus 0 1p
C332 bus 0 1p
C333 bus 0 1p
C334 bus 0 1p
C335 bus 0 1p
C336 bus 0 1p
C337 bus 0 1p
C338 bus 0 1p
C339 bus 0 1p
C340 bus 0 1p
C341 bus 0 1p
C342 bus 0 1p
C343 bus 0 1p
C344 bus 0 1p
C345 bus 0 1p
C346 bus 0 1p
C347 bus 0 1p
C348 bus 0 1p
C349 bus 0 1p
C350 bus 0 1p
C351 bus 0 1p
C352 bus 0 1p
C353 bus 0 1p
C354 bus 0 1p
C355 bus 0 1p
C356 bus 0 1p
C357 bus 0 1p
C358 bus 0 1p
C359 bus 0 1p
C360 bus 0 1p
C361 bus 0 1p
C362 bus 0 1p
C363 bus 0 1p
C364 bus 0 1p
C365 bus 0 1p
C366 bus 0 1p
C367 bus 0 1p
C368 bus 0 1p
C369 bus 0 1p
C370 bus 0 1p
C371 bus 0 1p
C372 bus 0 1p
C373 bus 0 1p
C374 bus 0 1p
C375 bus 0 1p
C376 bus 0 1p
C377 bus 0 1p
C378 bus 0 1p
C379 bus 0 1p
C380 bus 0 1p
C381 bus 0 1p
C382 bus 0 1p
C383 bus 0 1p
C384 bus 0 1p
C385 bus 0 1p
C386 bus 0 1p
C387 bus 0 1p
C388 bus 0 1p
C389 bus 0 1p
C390 bus 0 1p
C391 bus 0 1p
C392 bus 0 1p
C393 bus 0 1p
C394 bus 0 1p
C395 bus 0 1p
C396 bus 0 1p
C397 bus 0 1p
C398 bus 0 1p
C399 bus 0 1p
C400 bus 0 1p
C401 bus 0 1p
C402 bus 0 1p
C403 bus 0 1p
C404 bus 0 1p
C405 bus 0 1p
C406 bus 0 1p
C407 bus 0 1p
C408 bus 0 1p
C409 bus 0 1p
C410 bus 0 1p
C411 bus 0 1p
C412 bus 0 1p
C413 bus 0 1p
C414 bus 0 1p
C415 bus 0 1p
C416 bus 0 1p
C417 bus 0 1p
C418 bus 0 1p
C419 bus 0 1p
C420 bus 0 1p
C421 bus 0 1p
C422 bus 0 1p
C423 bus 0 1p
C424 bus 0 1p
C425 bus 0 1p
C426 bus 0 1p
C427 bus 0 1p
C428 bus 0 1p
C429 bus 0 1p
C430 bus 0 1p
C431 bus 0 1p
C432 bus 0 1p
C433 bus 0 1p
C434 bus 0 1p
C435 bus 0 1p
C436 bus 0 1p
C437 bus 0 1p
C438 bus 0 1p
C439 bus 0 1p
C440 bus 0 1p
C441 bus 0 1p
C442 bus 0 1p
C443 bus 0 1p
C444 bus 0 1p
C445 bus 0 1p
C446 bus 0 1p
C447 bus 0 1p
C448 bus 0 1p
C449 bus 0 1p
C450 bus 0 1p
C451 bus 0 1p
C452 bus 0 1p
C453 bus 0 1p
C454 bus 0 1p
C455 bus 0 1p
C456 bus 0 1p
C457 bus 0 1p
C458 bus 0 1p
C459 bus 0 1p
C460 bus 0 1p
C461 bus 0 1p
C462 bus 0 1p
C463 bus 0 1p
C464 bus 0 1p
C465 bus 0 1p
C466 bus 0 1p
C467 bus 0 1p
C468 bus 0 1p
C469 bus 0 1p
C470 bus 0 1p
C471 bus 0 1p
C472 bus 0 1p
C473 bus 0 1p
C474 bus 0 1p
C475 bus 0 1p
C476 bus 0 1p
C477 bus 0 1p
C478 bus 0 1p
C479 bus 0 1p
C480 bus 0 1p
C481 bus 0 1p
C482 bus 0 1p
C483 bus 0 1p
C484 bus 0 1p
C485 bus 0 1p
C486 bus 0 1p
C487 bus 0 1p
C488 bus 0 1p
C489 bus 0 1p
C490 bus 0 1p
C491 bus 0 1p
C492 bus 0 1p
C493 bus 0 1p
C494 bus 0 1p
C495 bus 0 1p
C496 bus 0 1p
C497 bus 0 1p
C498 bus 0 1p
C499 bus 0 1p
C500 bus 0 1p
C501 bus 0 1p
C502 bus 0 1p
C503 bus 0 1p
C504 bus 0 1p
C505 bus 0 1p
C506 bus 0 1p
C507 bus 0 1p
C508 bus 0 1p
C509 bus 0 1p
C510 bus 0 1p
C511 bus 0 1p
C512 bus 0 1p
C513 bus 0 1p
C514 bus 0 1p
C515 bus 0 1p
C516 bus 0 1p
C517 bus 0 1p
C518 bus 0 1p
C519 bus 0 1p
C520 bus 0 1p
C521 bus 0 1p
C522 bus 0 1p
C523 bus 0 1p
C524 bus 0 1p
C525 bus 0 1p
C526 bus 0 1p
C527 bus 0 1p
C528 bus 0 1p
C529 bus 0 1p
C530 bus 0 1p
C531 bus 0 1p
C532 bus 0 1p
C533 bus 0 1p
C534 bus 0 1p
C535 bus 0 1p
C536 bus 0 1p
C537 bus 0 1p
C538 bus 0 1p
C539 bus 0 1p
C540 bus 0 1p
C541 bus 0 1p
C542 bus 0 1p
C543 bus 0 1p
C544 bus 0 1p
C545 bus 0 1p
C546 bus 0 1p
C547 bus 0 1p
C548 bus 0 1p
C549 bus 0 1p
C550 bus 0 1p
C551 bus 0 1p
C552 bus 0 1p
C553 bus 0 1p
C554 bus 0 1p
C555 bus 0 1p
C556 bus 0 1p
C557 bus 0 1p
C558 bus 0 1p
C559 bus 0 1p
C560 bus 0 1p
C561 bus 0 1p
C562 bus 0 1p
C563 bus 0 1p
C564 bus 0 1p
C565 bus 0 1p
C566 bus 0 1p
C567 bus 0 1p
C568 bus 0 1p
C569 bus 0 1p
C570 bus 0 1p
C571 bus 0 1p
C572 bus 0 1p
C573 bus 0 1p
C574 bus 0 1p
C575 bus 0 1p
C576 bus 0 1p
C577 bus 0 1p
C578 bus 0 1p
C579 bus 0 1p
C580 bus 0 1p
C581 bus 0 1p
C582 bus 0 1p
C583 bus 0 1p
C584 bus 0 1p
C585 bus 0 1p
C586 bus 0 1p
C587 bus 0 1p
C588 bus 0 1p
C589 bus 0 1p
C590 bus 0 1p
C591 bus 0 1p
C592 bus 0 1p
C593 bus 0 1p
C594 bus 0 1p
C595 bus 0 1p
C596 bus 0 1p
C597 bus 0 1p
C598 bus 0 1p
C599 bus 0 1p
C600 bus 0 1p
C601 bus 0 1p
C602 bus 0 1p
C603 bus 0 1p
C604 bus 0 1p
C605 bus 0 1p
C606 bus 0 1p
C607 bus 0 1p
C608 bus 0 1p
C609 bus 0 1p
C610 bus 0 1p
C611 bus 0 1p
C612 bus 0 1p
C613 bus 0 1p
C614 bus 0 1p
C615 bus 0 1p
C616 bus 0 1p
C617 bus 0 1p
C618 bus 0 1p
C619 bus 0 1p
C620 bus 0 1p
C621 bus 0 1p
C622 bus 0 1p
C623 bus 0 1p
C624 bus 0 1p
C625 bus 0 1p
C626 bus 0 1p
C627 bus 0 1p
C628 bus 0 1p
C629 bus 0 1p
C630 bus 0 1p
C631 bus 0 1p
C632 bus 0 1p
C633 bus 0 1p
C634 bus 0 1p
C635 bus 0 1p
C636 bus 0 1p
C637 bus 0 1p
C638 bus 0 1p
C639 bus 0 1p
C640 bus 0 1p
C641 bus 0 1p
C642 bus 0 1p
C643 bus 0 1p
C644 bus 0 1p
C645 bus 0 1p
C646 bus 0 1p
C647 bus 0 1p
C648 bus 0 1p
C649 bus 0 1p
C650 bus 0 1p
C651 bus 0 1p
C652 bus 0 1p
C653 bus 0 1p
C654 bus 0 1p
C655 bus 0 1p
C656 bus 0 1p
C657 bus 0 1p
C658 bus 0 1p
C659 bus 0 1p
C660 bus 0 1p
C661 bus 0 1p
C662 bus 0 1p
C663 bus 0 1p
C664 bus 0 1p
C665 bus 0 1p
C666 bus 0 1p
C667 bus 0 1p
C668 bus 0 1p
C669 bus 0 1p
C670 bus 0 1p
C671 bus 0 1p
C672 bus 0 1p
C673 bus 0 1p
C674 bus 0 1p
C675 bus 0 1p
C676 bus 0 1p
C677 bus 0 1p
C678 bus 0 1p
C679 bus 0 1p
C680 bus 0 1p
C681 bus 0 1p
C682 bus 0 1p
C683 bus 0 1p
C684 bus 0 1p
C685 bus 0 1p
C686 bus 0 1p
C687 bus 0 1p
C688 bus 0 1p
C689 bus 0 1p
C690 bus 0 1p
C691 bus 0 1p
C692 bus 0 1p
C693 bus 0 1p
C694 bus 0 1p
C695 bus 0 1p
C696 bus 0 1p
C697 bus 0 1p
C698 bus 0 1p
C699 bus 0 1p
C700 bus 0 1p
C701 bus 0 1p
C702 bus 0 1p
C703 bus 0 1p
C704 bus 0 1p
C705 bus 0 1p
C706 bus 0 1p
C707 bus 0 1p
C708 bus 0 1p
C709 bus 0 1p
C710 bus 0 1p
C711 bus 0 1p
C712 bus 0 1p
C713 bus 0 1p
C714 bus 0 1p
C715 bus 0 1p
C716 bus 0 1p
C717 bus 0 1p
C718 bus 0 1p
C719 bus 0 1p
C720 bus 0 1p
C721 bus 0 1p
C722 bus 0 1p
C723 bus 0 1p
C724 bus 0 1p
C725 bus 0 1p
C726 bus 0 1p
C727 bus 0 1p
C728 bus 0 1p
C729 bus 0 1p
C730 bus 0 1p
C731 bus 0 1p
C732 bus 0 1p
C733 bus 0 1p
C734 bus 0 1p
C735 bus 0 1p
C736 bus 0 1p
C737 bus 0 1p
C738 bus 0 1p
C739 bus 0 1p
C740 bus 0 1p
C741 bus 0 1p
C742 bus 0 1p
C743 bus 0 1p
C744 bus 0 1p
C745 bus 0 1p
C746 bus 0 1p
C747 bus 0 1p
C748 bus 0 1p
C749 bus 0 1p
C750 bus 0 1p
C751 bus 0 1p
C752 bus 0 1p
C753 bus 0 1p
C754 bus 0 1p
C755 bus 0 1p
C756 bus 0 1p
C757 bus 0 1p
C758 bus 0 1p
C759 bus 0 1p
C760 bus 0 1p
C761 bus 0 1p
C762 bus 0 1p
C763 bus 0 1p
C764 bus 0 1p
C765 bus 0 1p
C766 bus 0 1p
C767 bus 0 1p
C768 bus 0 1p
C769 bus 0 1p
C770 bus 0 1p
C771 bus 0 1p
C772 bus 0 1p
C773 bus 0 1p
C774 bus 0 1p
C775 bus 0 1p
C776 bus 0 1p
C777 bus 0 1p
C778 bus 0 1p
C779 bus 0 1p
C780 bus 0 1p
C781 bus 0 1p
C782 bus 0 1p
C783 bus 0 1p
C784 bus 0 1p
C785 bus 0 1p
C786 bus 0 1p
C787 bus 0 1p
C788 bus 0 1p
C789 bus 0 1p
C790 bus 0 1p
C791 bus 0 1p
C792 bus 0 1p
C793 bus 0 1p
C794 bus 0 1p
C795 bus 0 1p
C796 bus 0 1p
C797 bus 0 1p
C798 bus 0 1p
C799 bus 0 1p
C800 bus 0 1p
C801 bus 0 1p
C802 bus 0 1p
C803 bus 0 1p
C804 bus 0 1p
C805 bus 0 1p
C806 bus 0 1p
C807 bus 0 1p
C808 bus 0 1p
C809 bus 0 1p
C810 bus 0 1p
C811 bus 0 1p
C812 bus 0 1p
C813 bus 0 1p
C814 bus 0 1p
C815 bus 0 1p
C816 bus 0 1p
C817 bus 0 1p
C818 bus 0 1p
C819 bus 0 1p
C820 bus 0 1p
C821 bus 0 1p
C822 bus 0 1p
C823 bus 0 1p
C824 bus 0 1p
C825 bus 0 1p
C826 bus 0 1p
C827 bus 0 1p
C828 bus 0 1p
C829 bus 0 1p
C830 bus 0 1p
C831 bus 0 1p
C832 bus 0 1p
C833 bus 0 1p
C834 bus 0 1p
C835 bus 0 1p
C836 bus 0 1p
C837 bus 0 1p
C838 bus 0 1p
C839 bus 0 1p
C840 bus 0 1p
C841 bus 0 1p
C842 bus 0 1p
C843 bus 0 1p
C844 bus 0 1p
C845 bus 0 1p
C846 bus 0 1p
C847 bus 0 1p
C848 bus 0 1p
C849 bus 0 1p
C850 bus 0 1p
C851 bus 0 1p
C852 bus 0 1p
C853 bus 0 1p
C854 bus 0 1p
C855 bus 0 1p
C856 bus 0 1p
C857 bus 0 1p
C858 bus 0 1p
C859 bus 0 1p
C860 bus 0 1p
C861 bus 0 1p
C862 bus 0 1p
C863 bus 0 1p
C864 bus 0 1p
C865 bus 0 1p
C866 bus 0 1p
C867 bus 0 1p
C868 bus 0 1p
C869 bus 0 1p
C870 bus 0 1p
C871 bus 0 1p
C872 bus 0 1p
C873 bus 0 1p
C874 bus 0 1p
C875 bus 0 1p
C876 bus 0 1p
C877 bus 0 1p
C878 bus 0 1p
C879 bus 0 1p
C880 bus 0 1p
C881 bus 0 1p
C882 bus 0 1p
C883 bus 0 1p
C884 bus 0 1p
C885 bus 0 1p
C886 bus 0 1p
C887 bus 0 1p
C888 bus 0 1p
C889 bus 0 1p
C890 bus 0 1p
C891 bus 0 1p
C892 bus 0 1p
C893 bus 0 1p
C894 bus 0 1p
C895 bus 0 1p
C896 bus 0 1p
C897 bus 0 1p
C898 bus 0 1p
C899 bus 0 1p
C900 bus 0 1p
C901 bus 0 1p
C902 bus 0 1p
C903 bus 0 1p
C904 bus 0 1p
C905 bus 0 1p
C906 bus 0 1p
C907 bus 0 1p
C908 bus 0 1p
C909 bus 0 1p
C910 bus 0 1p
C911 bus 0 1p
C912 bus 0 1p
C913 bus 0 1p
C914 bus 0 1p
C915 bus 0 1p
C916 bus 0 1p
C917 bus 0 1p
C918 bus 0 1p
C919 bus 0 1p
C920 bus 0 1p
C921 bus 0 1p
C922 bus 0 1p
C923 bus 0 1p
C924 bus 0 1p
C925 bus 0 1p
C926 bus 0 1p
C927 bus 0 1p
C928 bus 0 1p
C929 bus 0 1p
C930 bus 0 1p
C931 bus 0 1p
C932 bus 0 1p
C933 bus 0 1p
C934 bus 0 1p
C935 bus 0 1p
C936 bus 0 1p
C937 bus 0 1p
C938 bus 0 1p
C939 bus 0 1p
C940 bus 0 1p
C941 bus 0 1p
C942 bus 0 1p
C943 bus 0 1p
C944 bus 0 1p
C945 bus 0 1p
C946 bus 0 1p
C947 bus 0 1p
C948 bus 0 1p
C949 bus 0 1p
C950 bus 0 1p
C951 bus 0 1p
C952 bus 0 1p
C953 bus 0 1p
C954 bus 0 1p
C955 bus 0 1p
C956 bus 0 1p
C957 bus 0 1p
C958 bus 0 1p
C959 bus 0 1p
C960 bus 0 1p
C961 bus 0 1p
C962 bus 0 1p
C963 bus 0 1p
C964 bus 0 1p
C965 bus 0 1p
C966 bus 0 1p
C967 bus 0 1p
C968 bus 0 1p
C969 bus 0 1p
C970 bus 0 1p
C971 bus 0 1p
C972 bus 0 1p
C973 bus 0 1p
C974 bus 0 1p
C975 bus 0 1p
C976 bus 0 1p
C977 bus 0 1p
C978 bus 0 1p
C979 bus 0 1p
C980 bus 0 1p
C981 bus 0 1p
C982 bus 0 1p
C983 bus 0 1p
C984 bus 0 1p
C985 bus 0 1p
C986 bus 0 1p
C987 bus 0 1p
C988 bus 0 1p
C989 bus 0 1p
C990 bus 0 1p
C991 bus 0 1p
C992 bus 0 1p
C993 bus 0 1p
C994 bus 0 1p
C995 bus 0 1p
C996 bus 0 1p
C997 bus 0 1p
C998 bus 0 1p
C999 bus 0 1p
C1000 bus 0 1p
RL1 bus 0 1MEG
RL2 bus 0 1MEG
RL3 bus 0 1MEG
RL4 bus 0 1MEG
RL5 bus 0 1MEG
RL6 bus 0 1MEG
RL7 bus 0 1MEG
RL8 bus 0 1MEG
RL9 bus 0 1MEG
RL10 bus 0 1MEG
RL11 bus 0 1MEG
RL12 bus 0 1MEG
RL13 bus 0 1MEG
RL14 bus 0 1MEG
RL15 bus 0 1MEG
RL16 bus 0 1MEG
RL17 bus 0 1MEG
RL18 bus 0 1MEG
RL19 bus 0 1MEG
RL20 bus 0 1MEG
RL21 bus 0 1MEG
RL22 bus 0 1MEG
RL23 bus 0 1MEG
RL24 bus 0 1MEG
RL25 bus 0 1MEG
RL26 bus 0 1MEG
RL27 bus 0 1MEG
RL28 bus 0 1MEG
RL29 bus 0 1MEG
RL30 bus 0 1MEG
RL31 bus 0 1MEG
RL32 bus 0 1MEG
RL33 bus 0 1MEG
RL34 bus 0 1MEG
RL35 bus 0 1MEG
RL36 bus 0 1MEG
RL37 bus 0 1MEG
RL38 bus 0 1MEG
RL39 bus 0 1MEG
RL40 bus 0 1MEG
RL41 bus 0 1MEG
RL42 bus 0 1MEG
RL43 bus 0 1MEG
RL44 bus 0 1MEG
RL45 bus 0 1MEG
RL46 bus 0 1MEG
RL47 bus 0 1MEG
RL48 bus 0 1MEG
RL49 bus 0 1MEG
RL50 bus 0 1MEG
RL51 bus 0 1MEG
RL52 bus 0 1MEG
RL53 bus 0 1MEG
RL54 bus 0 1MEG
RL55 bus 0 1MEG
RL56 bus 0 1MEG
RL57 bus 0 1MEG
RL58 bus 0 1MEG
RL59 bus 0 1MEG
RL60 bus 0 1MEG
RL61 bus 0 1MEG
RL62 bus 0 1MEG
RL63 bus 0 1MEG
RL64 bus 0 1MEG
RL65 bus 0 1MEG
RL66 bus 0 1MEG
RL67 bus 0 1MEG
RL68 bus 0 1MEG
RL69 bus 0 1MEG
RL70 bus 0 1MEG
RL71 bus 0 1MEG
RL72 bus 0 1MEG
RL73 bus 0 1MEG
RL74 bus 0 1MEG
RL75 bus 0 1MEG
RL76 bus 0 1MEG
RL77 bus 0 1MEG
RL78 bus 0 1MEG
RL79 bus 0 1MEG
RL80 bus 0 1MEG
RL81 bus 0 1MEG
RL82 bus 0 1MEG
RL83 bus 0 1MEG
RL84 bus 0 1MEG
RL85 bus 0 1MEG
RL86 bus 0 1MEG
RL87 bus 0 1MEG
RL88 bus 0 1MEG
RL89 bus 0 1MEG
RL90 bus 0 1MEG
RL91 bus 0 1MEG
RL92 bus 0 1MEG
RL93 bus 0 1MEG
RL94 bus 0 1MEG
RL95 bus 0 1MEG
RL96 bus 0 1MEG
RL97 bus 0 1MEG
RL98 bus 0 1MEG
RL99 bus 0 1MEG
RL100 bus 0 1MEG
RL101 bus 0 1MEG
RL102 bus 0 1MEG
RL103 bus 0 1MEG
RL104 bus 0 1MEG
RL105 bus 0 1MEG
RL106 bus 0 1MEG
RL107 bus 0 1MEG
RL108 bus 0 1MEG
RL109 bus 0 1MEG
RL110 bus 0 1MEG
RL111 bus 0 1MEG
RL112 bus 0 1MEG
RL113 bus 0 1MEG
RL114 bus 0 1MEG
RL115 bus 0 1MEG
RL116 bus 0 1MEG
RL117 bus 0 1MEG
RL118 bus 0 1MEG
RL119 bus 0 1MEG
RL120 bus 0 1MEG
RL121 bus 0 1MEG
RL122 bus 0 1MEG
RL123 bus 0 1MEG
RL124 bus 0 1MEG
RL125 bus 0 1MEG
RL126 bus 0 1MEG
RL127 bus 0 1MEG
RL128 bus 0 1MEG
RL129 bus 0 1MEG
RL130 bus 0 1MEG
RL131 bus 0 1MEG
RL132 bus 0 1MEG
RL133 bus 0 1MEG
RL134 bus 0 1MEG
RL135 bus 0 1MEG
RL136 bus 0 1MEG
RL137 bus 0 1MEG
RL138 bus 0 1MEG
RL139 bus 0 1MEG
RL140 bus 0 1MEG
RL141 bus 0 1MEG
RL142 bus 0 1MEG
RL143 bus 0 1MEG
RL144 bus 0 1MEG
RL145 bus 0 1MEG
RL146 bus 0 1MEG
RL147 bus 0 1MEG
RL148 bus 0 1MEG
RL149 bus 0 1MEG
RL150 bus 0 1MEG
RL151 bus 0 1MEG
RL152 bus 0 1MEG
RL153 bus 0 1MEG
RL154 bus 0 1MEG
RL155 bus 0 1MEG
RL156 bus 0 1MEG
RL157 bus 0 1MEG
RL158 bus 0 1MEG
RL159 bus 0 1MEG
RL160 bus 0 1MEG
RL161 bus 0 1MEG
RL162 bus 0 1MEG
RL163 bus 0 1MEG
RL164 bus 0 1MEG
RL165 bus 0 1MEG
RL166 bus 0 1MEG
RL167 bus 0 1MEG
RL168 bus 0 1MEG
RL169 bus 0 1MEG
RL170 bus 0 1MEG
RL171 bus 0 1MEG
RL172 bus 0 1MEG
RL173 bus 0 1MEG
RL174 bus 0 1MEG
RL175 bus 0 1MEG
RL176 bus 0 1MEG
RL177 bus 0 1MEG
RL178 bus 0 1MEG
RL179 bus 0 1MEG
RL180 bus 0 1MEG
RL181 bus 0 1MEG
RL182 bus 0 1MEG
RL183 bus 0 1MEG
RL184 bus 0 1MEG
RL185 bus 0 1MEG
RL186 bus 0 1MEG
RL187 bus 0 1MEG
RL188 bus 0 1MEG
RL189 bus 0 1MEG
RL190 bus 0 1MEG
RL191 bus 0 1MEG
RL192 bus 0 1MEG
RL193 bus 0 1MEG
RL194 bus 0 1MEG
RL195 bus 0 1MEG
RL196 bus 0 1MEG
RL197 bus 0 1MEG
RL198 bus 0 1MEG
RL199 bus 0 1MEG
RL200 bus 0 1MEG
RL201 bus 0 1MEG
RL202 bus 0 1MEG
RL203 bus 0 1MEG
RL204 bus 0 1MEG
RL205 bus 0 1MEG
RL206 bus 0 1MEG
RL207 bus 0 1MEG
RL208 bus 0 1MEG
RL209 bus 0 1MEG
RL210 bus 0 1MEG
RL211 bus 0 1MEG
RL212 bus 0 1MEG
RL213 bus 0 1MEG
RL214 bus 0 1MEG
RL215 bus 0 1MEG
RL216 bus 0 1MEG
RL217 bus 0 1MEG
RL218 bus 0 1MEG
RL219 bus 0 1MEG
RL220 bus 0 1MEG
RL221 bus 0 1MEG
RL222 bus 0 1MEG
RL223 bus 0 1MEG
RL224 bus 0 1MEG
RL225 bus 0 1MEG
RL226 bus 0 1MEG
RL227 bus 0 1MEG
RL228 bus 0 1MEG
RL229 bus 0 1MEG
RL230 bus 0 1MEG
RL231 bus 0 1MEG
RL232 bus 0 1MEG
RL233 bus 0 1MEG
RL234 bus 0 1MEG
RL235 bus 0 1MEG
RL236 bus 0 1MEG
RL237 bus 0 1MEG
RL238 bus 0 1MEG
RL239 bus 0 1MEG
RL240 bus 0 1MEG
RL241 bus 0 1MEG
RL242 bus 0 1MEG
RL243 bus 0 1MEG
RL244 bus 0 1MEG
RL245 bus 0 1MEG
RL246 bus 0 1MEG
RL247 bus 0 1MEG
RL248 bus 0 1MEG
RL249 bus 0 1MEG
RL250 bus 0 1MEG
RL251 bus 0 1MEG
RL252 bus 0 1MEG
RL253 bus 0 1MEG
RL254 bus 0 1MEG
RL255 bus 0 1MEG
RL256 bus 0 1MEG
RL257 bus 0 1MEG
RL258 bus 0 1MEG
RL259 bus 0 1MEG
RL260 bus 0 1MEG
RL261 bus 0 1MEG
RL262 bus 0 1MEG
RL263 bus 0 1MEG
RL264 bus 0 1MEG
RL265 bus 0 1MEG
RL266 bus 0 1MEG
RL267 bus 0 1MEG
RL268 bus 0 1MEG
RL269 bus 0 1MEG
RL270 bus 0 1MEG
RL271 bus 0 1MEG
RL272 bus 0 1MEG
RL273 bus 0 1MEG
RL274 bus 0 1MEG
RL275 bus 0 1MEG
RL276 bus 0 1MEG
RL277 bus 0 1MEG
RL278 bus 0 1MEG
RL279 bus 0 1MEG
RL280 bus 0 1MEG
RL281 bus 0 1MEG
RL282 bus 0 1MEG
RL283 bus 0 1MEG
RL284 bus 0 1MEG
RL285 bus 0 1MEG
RL286 bus 0 1MEG
RL287 bus 0 1MEG
RL288 bus 0 1MEG
RL289 bus 0 1MEG
RL290 bus 0 1MEG
RL291 bus 0 1MEG
RL292 bus 0 1MEG
RL293 bus 0 1MEG
RL294 bus 0 1MEG
RL295 bus 0 1MEG
RL296 bus 0 1MEG
RL297 bus 0 1MEG
RL298 bus 0 1MEG
RL299 bus 0 1MEG
RL300 bus 0 1MEG
RL301 bus 0 1MEG
RL302 bus 0 1MEG
RL303 bus 0 1MEG
RL304 bus 0 1MEG
RL305 bus 0 1MEG
RL306 bus 0 1MEG
RL307 bus 0 1MEG
RL308 bus 0 1MEG
RL309 bus 0 1MEG
RL310 bus 0 1MEG
RL311 bus 0 1MEG
RL312 bus 0 1MEG
RL313 bus 0 1MEG
RL314 bus 0 1MEG
RL315 bus 0 1MEG
RL316 bus 0 1MEG
RL317 bus 0 1MEG
RL318 bus 0 1MEG
RL319 bus 0 1MEG
RL320 bus 0 1MEG
RL321 bus 0 1MEG
RL322 bus 0 1MEG
RL323 bus 0 1MEG
RL324 bus 0 1MEG
RL325 bus 0 1MEG
RL326 bus 0 1MEG
RL327 bus 0 1MEG
RL328 bus 0 1MEG
RL329 bus 0 1MEG
RL330 bus 0 1MEG
RL331 bus 0 1MEG
RL332 bus 0 1MEG
RL333 bus 0 1MEG
RL334 bus 0 1MEG
RL335 bus 0 1MEG
RL336 bus 0 1MEG
RL337 bus 0 1MEG
RL338 bus 0 1MEG
RL339 bus 0 1MEG
RL340 bus 0 1MEG
RL341 bus 0 1MEG
RL342 bus 0 1MEG
RL343 bus 0 1MEG
RL344 bus 0 1MEG
RL345 bus 0 1MEG
RL346 bus 0 1MEG
RL347 bus 0 1MEG
RL348 bus 0 1MEG
RL349 bus 0 1MEG
RL350 bus 0 1MEG
RL351 bus 0 1MEG
RL352 bus 0 1MEG
RL353 bus 0 1MEG
RL354 bus 0 1MEG
RL355 bus 0 1MEG
RL356 bus 0 1MEG
RL357 bus 0 1MEG
RL358 bus 0 1MEG
RL359 bus 0 1MEG
RL360 bus 0 1MEG
RL361 bus 0 1MEG
RL362 bus 0 1MEG
RL363 bus 0 1MEG
RL364 bus 0 1MEG
RL365 bus 0 1MEG
RL366 bus 0 1MEG
RL367 bus 0 1MEG
RL368 bus 0 1MEG
RL369 bus 0 1MEG
RL370 bus 0 1MEG
RL371 bus 0 1MEG
RL372 bus 0 1MEG
RL373 bus 0 1MEG
RL374 bus 0 1MEG
RL375 bus 0 1MEG
RL376 bus 0 1MEG
RL377 bus 0 1MEG
RL378 bus 0 1MEG
RL379 bus 0 1MEG
RL380 bus 0 1MEG
RL381 bus 0 1MEG
RL382 bus 0 1MEG
RL383 bus 0 1MEG
RL384 bus 0 1MEG
RL385 bus 0 1MEG
RL386 bus 0 1MEG
RL387 bus 0 1MEG
RL388 bus 0 1MEG
RL389 bus 0 1MEG
RL390 bus 0 1MEG
RL391 bus 0 1MEG
RL392 bus 0 1MEG
RL393 bus 0 1MEG
RL394 bus 0 1MEG
RL395 bus 0 1MEG
RL396 bus 0 1MEG
RL397 bus 0 1MEG
RL398 bus 0 1MEG
RL399 bus 0 1MEG
RL400 bus 0 1MEG
RL401 bus 0 1MEG
RL402 bus 0 1MEG
RL403 bus 0 1MEG
RL404 bus 0 1MEG
RL405 bus 0 1MEG
RL406 bus 0 1MEG
RL407 bus 0 1MEG
RL408 bus 0 1MEG
RL409 bus 0 1MEG
RL410 bus 0 1MEG
RL411 bus 0 1MEG
RL412 bus 0 1MEG
RL413 bus 0 1MEG
RL414 bus 0 1MEG
RL415 bus 0 1MEG
RL416 bus 0 1MEG
RL417 bus 0 1MEG
RL418 bus 0 1MEG
RL419 bus 0 1MEG
RL420 bus 0 1MEG
RL421 bus 0 1MEG
RL422 bus 0 1MEG
RL423 bus 0 1MEG
RL424 bus 0 1MEG
RL425 bus 0 1MEG
RL426 bus 0 1MEG
RL427 bus 0 1MEG
RL428 bus 0 1MEG
RL429 bus 0 1MEG
RL430 bus 0 1MEG
RL431 bus 0 1MEG
RL432 bus 0 1MEG
RL433 bus 0 1MEG
RL434 bus 0 1MEG
RL435 bus 0 1MEG
RL436 bus 0 1MEG
RL437 bus 0 1MEG
RL438 bus 0 1MEG
RL439 bus 0 1MEG
RL440 bus 0 1MEG
RL441 bus 0 1MEG
RL442 bus 0 1MEG
RL443 bus 0 1MEG
RL444 bus 0 1MEG
RL445 bus 0 1MEG
RL446 bus 0 1MEG
RL447 bus 0 1MEG
RL448 bus 0 1MEG
RL449 bus 0 1MEG
RL450 bus 0 1MEG
RL451 bus 0 1MEG
RL452 bus 0 1MEG
RL453 bus 0 1MEG
RL454 bus 0 1MEG
RL455 bus 0 1MEG
RL456 bus 0 1MEG
RL457 bus 0 1MEG
RL458 bus 0 1MEG
RL459 bus 0 1MEG
RL460 bus 0 1MEG
RL461 bus 0 1MEG
RL462 bus 0 1MEG
RL463 bus 0 1MEG
RL464 bus 0 1MEG
RL465 bus 0 1MEG
RL466 bus 0 1MEG
RL467 bus 0 1MEG
RL468 bus 0 1MEG
RL469 bus 0 1MEG
RL470 bus 0 1MEG
RL471 bus 0 1MEG
RL472 bus 0 1MEG
RL473 bus 0 1MEG
RL474 bus 0 1MEG
RL475 bus 0 1MEG
RL476 bus 0 1MEG
RL477 bus 0 1MEG
RL478 bus 0 1MEG
RL479 bus 0 1MEG
RL480 bus 0 1MEG
RL481 bus 0 1MEG
RL482 bus 0 1MEG
RL483 bus 0 1MEG
RL484 bus 0 1MEG
RL485 bus 0 1MEG
RL486 bus 0 1MEG
RL487 bus 0 1MEG
RL488 bus 0 1MEG
RL489 bus 0 1MEG
RL490 bus 0 1MEG
RL491 bus 0 1MEG
RL492 bus 0 1MEG
RL493 bus 0 1MEG
RL494 bus 0 1MEG
RL495 bus 0 1MEG
RL496 bus 0 1MEG
RL497 bus 0 1MEG
RL498 bus 0 1MEG
RL499 bus 0 1MEG
RL500 bus 0 1MEG
RL501 bus 0 1MEG
RL502 bus 0 1MEG
RL503 bus 0 1MEG
RL504 bus 0 1MEG
RL505 bus 0 1MEG
RL506 bus 0 1MEG
RL507 bus 0 1MEG
RL508 bus 0 1MEG
RL509 bus 0 1MEG
RL510 bus 0 1MEG
RL511 bus 0 1MEG
RL512 bus 0 1MEG
RL513 bus 0 1MEG
RL514 bus 0 1MEG
RL515 bus 0 1MEG
RL516 bus 0 1MEG
RL517 bus 0 1MEG
RL518 bus 0 1MEG
RL519 bus 0 1MEG
RL520 bus 0 1MEG
RL521 bus 0 1MEG
RL522 bus 0 1MEG
RL523 bus 0 1MEG
RL524 bus 0 1MEG
RL525 bus 0 1MEG
RL526 bus 0 1MEG
RL527 bus 0 1MEG
RL528 bus 0 1MEG
RL529 bus 0 1MEG
RL530 bus 0 1MEG
RL531 bus 0 1MEG
RL532 bus 0 1MEG
RL533 bus 0 1MEG
RL534 bus 0 1MEG
RL535 bus 0 1MEG
RL536 bus 0 1MEG
RL537 bus 0 1MEG
RL538 bus 0 1MEG
RL539 bus 0 1MEG
RL540 bus 0 1MEG
RL541 bus 0 1MEG
RL542 bus 0 1MEG
RL543 bus 0 1MEG
RL544 bus 0 1MEG
RL545 bus 0 1MEG
RL546 bus 0 1MEG
RL547 bus 0 1MEG
RL548 bus 0 1MEG
RL549 bus 0 1MEG
RL550 bus 0 1MEG
RL551 bus 0 1MEG
RL552 bus 0 1MEG
RL553 bus 0 1MEG
RL554 bus 0 1MEG
RL555 bus 0 1MEG
RL556 bus 0 1MEG
RL557 bus 0 1MEG
RL558 bus 0 1MEG
RL559 bus 0 1MEG
RL560 bus 0 1MEG
RL561 bus 0 1MEG
RL562 bus 0 1MEG
RL563 bus 0 1MEG
RL564 bus 0 1MEG
RL565 bus 0 1MEG
RL566 bus 0 1MEG
RL567 bus 0 1MEG
RL568 bus 0 1MEG
RL569 bus 0 1MEG
RL570 bus 0 1MEG
RL571 bus 0 1MEG
RL572 bus 0 1MEG
RL573 bus 0 1MEG
RL574 bus 0 1MEG
RL575 bus 0 1MEG
RL576 bus 0 1MEG
RL577 bus 0 1MEG
RL578 bus 0 1MEG
RL579 bus 0 1MEG
RL580 bus 0 1MEG
RL581 bus 0 1MEG
RL582 bus 0 1MEG
RL583 bus 0 1MEG
RL584 bus 0 1MEG
RL585 bus 0 1MEG
RL586 bus 0 1MEG
RL587 bus 0 1MEG
RL588 bus 0 1MEG
RL589 bus 0 1MEG
RL590 bus 0 1MEG
RL591 bus 0 1MEG
RL592 bus 0 1MEG
RL593 bus 0 1MEG
RL594 bus 0 1MEG
RL595 bus 0 1MEG
RL596 bus 0 1MEG
RL597 bus 0 1MEG
RL598 bus 0 1MEG
RL599 bus 0 1MEG
RL600 bus 0 1MEG
RL601 bus 0 1MEG
RL602 bus 0 1MEG
RL603 bus 0 1MEG
RL604 bus 0 1MEG
RL605 bus 0 1MEG
RL606 bus 0 1MEG
RL607 bus 0 1MEG
RL608 bus 0 1MEG
RL609 bus 0 1MEG
RL610 bus 0 1MEG
RL611 bus 0 1MEG
RL612 bus 0 1MEG
RL613 bus 0 1MEG
RL614 bus 0 1MEG
RL615 bus 0 1MEG
RL616 bus 0 1MEG
RL617 bus 0 1MEG
RL618 bus 0 1MEG
RL619 bus 0 1MEG
RL620 bus 0 1MEG
RL621 bus 0 1MEG
RL622 bus 0 1MEG
RL623 bus 0 1MEG
RL624 bus 0 1MEG
RL625 bus 0 1MEG
RL626 bus 0 1MEG
RL627 bus 0 1MEG
RL628 bus 0 1MEG
RL629 bus 0 1MEG
RL630 bus 0 1MEG
RL631 bus 0 1MEG
RL632 bus 0 1MEG
RL633 bus 0 1MEG
RL634 bus 0 1MEG
RL635 bus 0 1MEG
RL636 bus 0 1MEG
RL637 bus 0 1MEG
RL638 bus 0 1MEG
RL639 bus 0 1MEG
RL640 bus 0 1MEG
RL641 bus 0 1MEG
RL642 bus 0 1MEG
RL643 bus 0 1MEG
RL644 bus 0 1MEG
RL645 bus 0 1MEG
RL646 bus 0 1MEG
RL647 bus 0 1MEG
RL648 bus 0 1MEG
RL649 bus 0 1MEG
RL650 bus 0 1MEG
RL651 bus 0 1MEG
RL652 bus 0 1MEG
RL653 bus 0 1MEG
RL654 bus 0 1MEG
RL655 bus 0 1MEG
RL656 bus 0 1MEG
RL657 bus 0 1MEG
RL658 bus 0 1MEG
RL659 bus 0 1MEG
RL660 bus 0 1MEG
RL661 bus 0 1MEG
RL662 bus 0 1MEG
RL663 bus 0 1MEG
RL664 bus 0 1MEG
RL665 bus 0 1MEG
RL666 bus 0 1MEG
RL667 bus 0 1MEG
RL668 bus 0 1MEG
RL669 bus 0 1MEG
RL670 bus 0 1MEG
RL671 bus 0 1MEG
RL672 bus 0 1MEG
RL673 bus 0 1MEG
RL674 bus 0 1MEG
RL675 bus 0 1MEG
RL676 bus 0 1MEG
RL677 bus 0 1MEG
RL678 bus 0 1MEG
RL679 bus 0 1MEG
RL680 bus 0 1MEG
RL681 bus 0 1MEG
RL682 bus 0 1MEG
RL683 bus 0 1MEG
RL684 bus 0 1MEG
RL685 bus 0 1MEG
RL686 bus 0 1MEG
RL687 bus 0 1MEG
RL688 bus 0 1MEG
RL689 bus 0 1MEG
RL690 bus 0 1MEG
RL691 bus 0 1MEG
RL692 bus 0 1MEG
RL693 bus 0 1MEG
RL694 bus 0 1MEG
RL695 bus 0 1MEG
RL696 bus 0 1MEG
RL697 bus 0 1MEG
RL698 bus 0 1MEG
RL699 bus 0 1MEG
RL700 bus 0 1MEG
RL701 bus 0 1MEG
RL702 bus 0 1MEG
RL703 bus 0 1MEG
RL704 bus 0 1MEG
RL705 bus 0 1MEG
RL706 bus 0 1MEG
RL707 bus 0 1MEG
RL708 bus 0 1MEG
RL709 bus 0 1MEG
RL710 bus 0 1MEG
RL711 bus 0 1MEG
RL712 bus 0 1MEG
RL713 bus 0 1MEG
RL714 bus 0 1MEG
RL715 bus 0 1MEG
RL716 bus 0 1MEG
RL717 bus 0 1MEG
RL718 bus 0 1MEG
RL719 bus 0 1MEG
RL720 bus 0 1MEG
RL721 bus 0 1MEG
RL722 bus 0 1MEG
RL723 bus 0 1MEG
RL724 bus 0 1MEG
RL725 bus 0 1MEG
RL726 bus 0 1MEG
RL727 bus 0 1MEG
RL728 bus 0 1MEG
RL729 bus 0 1MEG
RL730 bus 0 1MEG
RL731 bus 0 1MEG
RL732 bus 0 1MEG
RL733 bus 0 1MEG
RL734 bus 0 1MEG
RL735 bus 0 1MEG
RL736 bus 0 1MEG
RL737 bus 0 1MEG
RL738 bus 0 1MEG
RL739 bus 0 1MEG
RL740 bus 0 1MEG
RL741 bus 0 1MEG
RL742 bus 0 1MEG
RL743 bus 0 1MEG
RL744 bus 0 1MEG
RL745 bus 0 1MEG
RL746 bus 0 1MEG
RL747 bus 0 1MEG
RL748 bus 0 1MEG
RL749 bus 0 1MEG
RL750 bus 0 1MEG
RL751 bus 0 1MEG
RL752 bus 0 1MEG
RL753 bus 0 1MEG
RL754 bus 0 1MEG
RL755 bus 0 1MEG
RL756 bus 0 1MEG
RL757 bus 0 1MEG
RL758 bus 0 1MEG
RL759 bus 0 1MEG
RL760 bus 0 1MEG
RL761 bus 0 1MEG
RL762 bus 0 1MEG
RL763 bus 0 1MEG
RL764 bus 0 1MEG
RL765 bus 0 1MEG
RL766 bus 0 1MEG
RL767 bus 0 1MEG
RL768 bus 0 1MEG
RL769 bus 0 1MEG
RL770 bus 0 1MEG
RL771 bus 0 1MEG
RL772 bus 0 1MEG
RL773 bus 0 1MEG
RL774 bus 0 1MEG
RL775 bus 0 1MEG
RL776 bus 0 1MEG
RL777 bus 0 1MEG
RL778 bus 0 1MEG
RL779 bus 0 1MEG
RL780 bus 0 1MEG
RL781 bus 0 1MEG
RL782 bus 0 1MEG
RL783 bus 0 1MEG
RL784 bus 0 1MEG
RL785 bus 0 1MEG
RL786 bus 0 1MEG
RL787 bus 0 1MEG
RL788 bus 0 1MEG
RL789 bus 0 1MEG
RL790 bus 0 1MEG
RL791 bus 0 1MEG
RL792 bus 0 1MEG
RL793 bus 0 1MEG
RL794 bus 0 1MEG
RL795 bus 0 1MEG
RL796 bus 0 1MEG
RL797 bus 0 1MEG
RL798 bus 0 1MEG
RL799 bus 0 1MEG
RL800 bus 0 1MEG
RL801 bus 0 1MEG
RL802 bus 0 1MEG
RL803 bus 0 1MEG
RL804 bus 0 1MEG
RL805 bus 0 1MEG
RL806 bus 0 1MEG
RL807 bus 0 1MEG
RL808 bus 0 1MEG
RL809 bus 0 1MEG
RL810 bus 0 1MEG
RL811 bus 0 1MEG
RL812 bus 0 1MEG
RL813 bus 0 1MEG
RL814 bus 0 1MEG
RL815 bus 0 1MEG
RL816 bus 0 1MEG
RL817 bus 0 1MEG
RL818 bus 0 1MEG
RL819 bus 0 1MEG
RL820 bus 0 1MEG
RL821 bus 0 1MEG
RL822 bus 0 1MEG
RL823 bus 0 1MEG
RL824 bus 0 1MEG
RL825 bus 0 1MEG
RL826 bus 0 1MEG
RL827 bus 0 1MEG
RL828 bus 0 1MEG
RL829 bus 0 1MEG
RL830 bus 0 1MEG
RL831 bus 0 1MEG
RL832 bus 0 1MEG
RL833 bus 0 1MEG
RL834 bus 0 1MEG
RL835 bus 0 1MEG
RL836 bus 0 1MEG
RL837 bus 0 1MEG
RL838 bus 0 1MEG
RL839 bus 0 1MEG
RL840 bus 0 1MEG
RL841 bus 0 1MEG
RL842 bus 0 1MEG
RL843 bus 0 1MEG
RL844 bus 0 1MEG
RL845 bus 0 1MEG
RL846 bus 0 1MEG
RL847 bus 0 1MEG
RL848 bus 0 1MEG
RL849 bus 0 1MEG
RL850 bus 0 1MEG
RL851 bus 0 1MEG
RL852 bus 0 1MEG
RL853 bus 0 1MEG
RL854 bus 0 1MEG
RL855 bus 0 1MEG
RL856 bus 0 1MEG
RL857 bus 0 1MEG
RL858 bus 0 1MEG
RL859 bus 0 1MEG
RL860 bus 0 1MEG
RL861 bus 0 1MEG
RL862 bus 0 1MEG
RL863 bus 0 1MEG
RL864 bus 0 1MEG
RL865 bus 0 1MEG
RL866 bus 0 1MEG
RL867 bus 0 1MEG
RL868 bus 0 1MEG
RL869 bus 0 1MEG
RL870 bus 0 1MEG
RL871 bus 0 1MEG
RL872 bus 0 1MEG
RL873 bus 0 1MEG
RL874 bus 0 1MEG
RL875 bus 0 1MEG
RL876 bus 0 1MEG
RL877 bus 0 1MEG
RL878 bus 0 1MEG
RL879 bus 0 1MEG
RL880 bus 0 1MEG
RL881 bus 0 1MEG
RL882 bus 0 1MEG
RL883 bus 0 1MEG
RL884 bus 0 1MEG
RL885 bus 0 1MEG
RL886 bus 0 1MEG
RL887 bus 0 1MEG
RL888 bus 0 1MEG
RL889 bus 0 1MEG
RL890 bus 0 1MEG
RL891 bus 0 1MEG
RL892 bus 0 1MEG
RL893 bus 0 1MEG
RL894 bus 0 1MEG
RL895 bus 0 1MEG
RL896 bus 0 1MEG
RL897 bus 0 1MEG
RL898 bus 0 1MEG
RL899 bus 0 1MEG
RL900 bus 0 1MEG
RL901 bus 0 1MEG
RL902 bus 0 1MEG
RL903 bus 0 1MEG
RL904 bus 0 1MEG
RL905 bus 0 1MEG
RL906 bus 0 1MEG
RL907 bus 0 1MEG
RL908 bus 0 1MEG
RL909 bus 0 1MEG
RL910 bus 0 1MEG
RL911 bus 0 1MEG
RL912 bus 0 1MEG
RL913 bus 0 1MEG
RL914 bus 0 1MEG
RL915 bus 0 1MEG
RL916 bus 0 1MEG
RL917 bus 0 1MEG
RL918 bus 0 1MEG
RL919 bus 0 1MEG
RL920 bus 0 1MEG
RL921 bus 0 1MEG
RL922 bus 0 1MEG
RL923 bus 0 1MEG
RL924 bus 0 1MEG
RL925 bus 0 1MEG
RL926 bus 0 1MEG
RL927 bus 0 1MEG
RL928 bus 0 1MEG
RL929 bus 0 1MEG
RL930 bus 0 1MEG
RL931 bus 0 1MEG
RL932 bus 0 1MEG
RL933 bus 0 1MEG
RL934 bus 0 1MEG
RL935 bus 0 1MEG
RL936 bus 0 1MEG
RL937 bus 0 1MEG
RL938 bus 0 1MEG
RL939 bus 0 1MEG
RL940 bus 0 1MEG
RL941 bus 0 1MEG
RL942 bus 0 1MEG
RL943 bus 0 1MEG
RL944 bus 0 1MEG
RL945 bus 0 1MEG
RL946 bus 0 1MEG
RL947 bus 0 1MEG
RL948 bus 0 1MEG
RL949 bus 0 1MEG
RL950 bus 0 1MEG
RL951 bus 0 1MEG
RL952 bus 0 1MEG
RL953 bus 0 1MEG
RL954 bus 0 1MEG
RL955 bus 0 1MEG
RL956 bus 0 1MEG
RL957 bus 0 1MEG
RL958 bus 0 1MEG
RL959 bus 0 1MEG
RL960 bus 0 1MEG
RL961 bus 0 1MEG
RL962 bus 0 1MEG
RL963 bus 0 1MEG
RL964 bus 0 1MEG
RL965 bus 0 1MEG
RL966 bus 0 1MEG
RL967 bus 0 1MEG
RL968 bus 0 1MEG
RL969 bus 0 1MEG
RL970 bus 0 1MEG
RL971 bus 0 1MEG
RL972 bus 0 1MEG
RL973 bus 0 1MEG
RL974 bus 0 1MEG
RL975 bus 0 1MEG
RL976 bus 0 1MEG
RL977 bus 0 1MEG
RL978 bus 0 1MEG
RL979 bus 0 1MEG
RL980 bus 0 1MEG
RL981 bus 0 1MEG
RL982 bus 0 1MEG
RL983 bus 0 1MEG
RL984 bus 0 1MEG
RL985 bus 0 1MEG
RL986 bus 0 1MEG
RL987 bus 0 1MEG
RL988 bus 0 1MEG
RL989 bus 0 1MEG
RL990 bus 0 1MEG
RL991 bus 0 1MEG
RL992 bus 0 1MEG
RL993 bus 0 1MEG
RL994 bus 0 1MEG
RL995 bus 0 1MEG
RL996 bus 0 1MEG
RL997 bus 0 1MEG
RL998 bus 0 1MEG
RL999 bus 0 1MEG
RL1000 bus 0 1MEG

.TRAN 0.1n 5u
.END
