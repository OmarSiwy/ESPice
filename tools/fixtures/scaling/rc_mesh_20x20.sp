* RC Mesh — 20x20 grid
V1 1 0 PULSE(0 1 0 1n 1n 1u 2u)
RH1 1 2 1k
RH2 2 3 1k
RH3 3 4 1k
RH4 4 5 1k
RH5 5 6 1k
RH6 6 7 1k
RH7 7 8 1k
RH8 8 9 1k
RH9 9 10 1k
RH10 10 11 1k
RH11 11 12 1k
RH12 12 13 1k
RH13 13 14 1k
RH14 14 15 1k
RH15 15 16 1k
RH16 16 17 1k
RH17 17 18 1k
RH18 18 19 1k
RH19 19 20 1k
RH20 21 22 1k
RH21 22 23 1k
RH22 23 24 1k
RH23 24 25 1k
RH24 25 26 1k
RH25 26 27 1k
RH26 27 28 1k
RH27 28 29 1k
RH28 29 30 1k
RH29 30 31 1k
RH30 31 32 1k
RH31 32 33 1k
RH32 33 34 1k
RH33 34 35 1k
RH34 35 36 1k
RH35 36 37 1k
RH36 37 38 1k
RH37 38 39 1k
RH38 39 40 1k
RH39 41 42 1k
RH40 42 43 1k
RH41 43 44 1k
RH42 44 45 1k
RH43 45 46 1k
RH44 46 47 1k
RH45 47 48 1k
RH46 48 49 1k
RH47 49 50 1k
RH48 50 51 1k
RH49 51 52 1k
RH50 52 53 1k
RH51 53 54 1k
RH52 54 55 1k
RH53 55 56 1k
RH54 56 57 1k
RH55 57 58 1k
RH56 58 59 1k
RH57 59 60 1k
RH58 61 62 1k
RH59 62 63 1k
RH60 63 64 1k
RH61 64 65 1k
RH62 65 66 1k
RH63 66 67 1k
RH64 67 68 1k
RH65 68 69 1k
RH66 69 70 1k
RH67 70 71 1k
RH68 71 72 1k
RH69 72 73 1k
RH70 73 74 1k
RH71 74 75 1k
RH72 75 76 1k
RH73 76 77 1k
RH74 77 78 1k
RH75 78 79 1k
RH76 79 80 1k
RH77 81 82 1k
RH78 82 83 1k
RH79 83 84 1k
RH80 84 85 1k
RH81 85 86 1k
RH82 86 87 1k
RH83 87 88 1k
RH84 88 89 1k
RH85 89 90 1k
RH86 90 91 1k
RH87 91 92 1k
RH88 92 93 1k
RH89 93 94 1k
RH90 94 95 1k
RH91 95 96 1k
RH92 96 97 1k
RH93 97 98 1k
RH94 98 99 1k
RH95 99 100 1k
RH96 101 102 1k
RH97 102 103 1k
RH98 103 104 1k
RH99 104 105 1k
RH100 105 106 1k
RH101 106 107 1k
RH102 107 108 1k
RH103 108 109 1k
RH104 109 110 1k
RH105 110 111 1k
RH106 111 112 1k
RH107 112 113 1k
RH108 113 114 1k
RH109 114 115 1k
RH110 115 116 1k
RH111 116 117 1k
RH112 117 118 1k
RH113 118 119 1k
RH114 119 120 1k
RH115 121 122 1k
RH116 122 123 1k
RH117 123 124 1k
RH118 124 125 1k
RH119 125 126 1k
RH120 126 127 1k
RH121 127 128 1k
RH122 128 129 1k
RH123 129 130 1k
RH124 130 131 1k
RH125 131 132 1k
RH126 132 133 1k
RH127 133 134 1k
RH128 134 135 1k
RH129 135 136 1k
RH130 136 137 1k
RH131 137 138 1k
RH132 138 139 1k
RH133 139 140 1k
RH134 141 142 1k
RH135 142 143 1k
RH136 143 144 1k
RH137 144 145 1k
RH138 145 146 1k
RH139 146 147 1k
RH140 147 148 1k
RH141 148 149 1k
RH142 149 150 1k
RH143 150 151 1k
RH144 151 152 1k
RH145 152 153 1k
RH146 153 154 1k
RH147 154 155 1k
RH148 155 156 1k
RH149 156 157 1k
RH150 157 158 1k
RH151 158 159 1k
RH152 159 160 1k
RH153 161 162 1k
RH154 162 163 1k
RH155 163 164 1k
RH156 164 165 1k
RH157 165 166 1k
RH158 166 167 1k
RH159 167 168 1k
RH160 168 169 1k
RH161 169 170 1k
RH162 170 171 1k
RH163 171 172 1k
RH164 172 173 1k
RH165 173 174 1k
RH166 174 175 1k
RH167 175 176 1k
RH168 176 177 1k
RH169 177 178 1k
RH170 178 179 1k
RH171 179 180 1k
RH172 181 182 1k
RH173 182 183 1k
RH174 183 184 1k
RH175 184 185 1k
RH176 185 186 1k
RH177 186 187 1k
RH178 187 188 1k
RH179 188 189 1k
RH180 189 190 1k
RH181 190 191 1k
RH182 191 192 1k
RH183 192 193 1k
RH184 193 194 1k
RH185 194 195 1k
RH186 195 196 1k
RH187 196 197 1k
RH188 197 198 1k
RH189 198 199 1k
RH190 199 200 1k
RH191 201 202 1k
RH192 202 203 1k
RH193 203 204 1k
RH194 204 205 1k
RH195 205 206 1k
RH196 206 207 1k
RH197 207 208 1k
RH198 208 209 1k
RH199 209 210 1k
RH200 210 211 1k
RH201 211 212 1k
RH202 212 213 1k
RH203 213 214 1k
RH204 214 215 1k
RH205 215 216 1k
RH206 216 217 1k
RH207 217 218 1k
RH208 218 219 1k
RH209 219 220 1k
RH210 221 222 1k
RH211 222 223 1k
RH212 223 224 1k
RH213 224 225 1k
RH214 225 226 1k
RH215 226 227 1k
RH216 227 228 1k
RH217 228 229 1k
RH218 229 230 1k
RH219 230 231 1k
RH220 231 232 1k
RH221 232 233 1k
RH222 233 234 1k
RH223 234 235 1k
RH224 235 236 1k
RH225 236 237 1k
RH226 237 238 1k
RH227 238 239 1k
RH228 239 240 1k
RH229 241 242 1k
RH230 242 243 1k
RH231 243 244 1k
RH232 244 245 1k
RH233 245 246 1k
RH234 246 247 1k
RH235 247 248 1k
RH236 248 249 1k
RH237 249 250 1k
RH238 250 251 1k
RH239 251 252 1k
RH240 252 253 1k
RH241 253 254 1k
RH242 254 255 1k
RH243 255 256 1k
RH244 256 257 1k
RH245 257 258 1k
RH246 258 259 1k
RH247 259 260 1k
RH248 261 262 1k
RH249 262 263 1k
RH250 263 264 1k
RH251 264 265 1k
RH252 265 266 1k
RH253 266 267 1k
RH254 267 268 1k
RH255 268 269 1k
RH256 269 270 1k
RH257 270 271 1k
RH258 271 272 1k
RH259 272 273 1k
RH260 273 274 1k
RH261 274 275 1k
RH262 275 276 1k
RH263 276 277 1k
RH264 277 278 1k
RH265 278 279 1k
RH266 279 280 1k
RH267 281 282 1k
RH268 282 283 1k
RH269 283 284 1k
RH270 284 285 1k
RH271 285 286 1k
RH272 286 287 1k
RH273 287 288 1k
RH274 288 289 1k
RH275 289 290 1k
RH276 290 291 1k
RH277 291 292 1k
RH278 292 293 1k
RH279 293 294 1k
RH280 294 295 1k
RH281 295 296 1k
RH282 296 297 1k
RH283 297 298 1k
RH284 298 299 1k
RH285 299 300 1k
RH286 301 302 1k
RH287 302 303 1k
RH288 303 304 1k
RH289 304 305 1k
RH290 305 306 1k
RH291 306 307 1k
RH292 307 308 1k
RH293 308 309 1k
RH294 309 310 1k
RH295 310 311 1k
RH296 311 312 1k
RH297 312 313 1k
RH298 313 314 1k
RH299 314 315 1k
RH300 315 316 1k
RH301 316 317 1k
RH302 317 318 1k
RH303 318 319 1k
RH304 319 320 1k
RH305 321 322 1k
RH306 322 323 1k
RH307 323 324 1k
RH308 324 325 1k
RH309 325 326 1k
RH310 326 327 1k
RH311 327 328 1k
RH312 328 329 1k
RH313 329 330 1k
RH314 330 331 1k
RH315 331 332 1k
RH316 332 333 1k
RH317 333 334 1k
RH318 334 335 1k
RH319 335 336 1k
RH320 336 337 1k
RH321 337 338 1k
RH322 338 339 1k
RH323 339 340 1k
RH324 341 342 1k
RH325 342 343 1k
RH326 343 344 1k
RH327 344 345 1k
RH328 345 346 1k
RH329 346 347 1k
RH330 347 348 1k
RH331 348 349 1k
RH332 349 350 1k
RH333 350 351 1k
RH334 351 352 1k
RH335 352 353 1k
RH336 353 354 1k
RH337 354 355 1k
RH338 355 356 1k
RH339 356 357 1k
RH340 357 358 1k
RH341 358 359 1k
RH342 359 360 1k
RH343 361 362 1k
RH344 362 363 1k
RH345 363 364 1k
RH346 364 365 1k
RH347 365 366 1k
RH348 366 367 1k
RH349 367 368 1k
RH350 368 369 1k
RH351 369 370 1k
RH352 370 371 1k
RH353 371 372 1k
RH354 372 373 1k
RH355 373 374 1k
RH356 374 375 1k
RH357 375 376 1k
RH358 376 377 1k
RH359 377 378 1k
RH360 378 379 1k
RH361 379 380 1k
RH362 381 382 1k
RH363 382 383 1k
RH364 383 384 1k
RH365 384 385 1k
RH366 385 386 1k
RH367 386 387 1k
RH368 387 388 1k
RH369 388 389 1k
RH370 389 390 1k
RH371 390 391 1k
RH372 391 392 1k
RH373 392 393 1k
RH374 393 394 1k
RH375 394 395 1k
RH376 395 396 1k
RH377 396 397 1k
RH378 397 398 1k
RH379 398 399 1k
RH380 399 400 1k
RV381 1 21 1k
RV382 2 22 1k
RV383 3 23 1k
RV384 4 24 1k
RV385 5 25 1k
RV386 6 26 1k
RV387 7 27 1k
RV388 8 28 1k
RV389 9 29 1k
RV390 10 30 1k
RV391 11 31 1k
RV392 12 32 1k
RV393 13 33 1k
RV394 14 34 1k
RV395 15 35 1k
RV396 16 36 1k
RV397 17 37 1k
RV398 18 38 1k
RV399 19 39 1k
RV400 20 40 1k
RV401 21 41 1k
RV402 22 42 1k
RV403 23 43 1k
RV404 24 44 1k
RV405 25 45 1k
RV406 26 46 1k
RV407 27 47 1k
RV408 28 48 1k
RV409 29 49 1k
RV410 30 50 1k
RV411 31 51 1k
RV412 32 52 1k
RV413 33 53 1k
RV414 34 54 1k
RV415 35 55 1k
RV416 36 56 1k
RV417 37 57 1k
RV418 38 58 1k
RV419 39 59 1k
RV420 40 60 1k
RV421 41 61 1k
RV422 42 62 1k
RV423 43 63 1k
RV424 44 64 1k
RV425 45 65 1k
RV426 46 66 1k
RV427 47 67 1k
RV428 48 68 1k
RV429 49 69 1k
RV430 50 70 1k
RV431 51 71 1k
RV432 52 72 1k
RV433 53 73 1k
RV434 54 74 1k
RV435 55 75 1k
RV436 56 76 1k
RV437 57 77 1k
RV438 58 78 1k
RV439 59 79 1k
RV440 60 80 1k
RV441 61 81 1k
RV442 62 82 1k
RV443 63 83 1k
RV444 64 84 1k
RV445 65 85 1k
RV446 66 86 1k
RV447 67 87 1k
RV448 68 88 1k
RV449 69 89 1k
RV450 70 90 1k
RV451 71 91 1k
RV452 72 92 1k
RV453 73 93 1k
RV454 74 94 1k
RV455 75 95 1k
RV456 76 96 1k
RV457 77 97 1k
RV458 78 98 1k
RV459 79 99 1k
RV460 80 100 1k
RV461 81 101 1k
RV462 82 102 1k
RV463 83 103 1k
RV464 84 104 1k
RV465 85 105 1k
RV466 86 106 1k
RV467 87 107 1k
RV468 88 108 1k
RV469 89 109 1k
RV470 90 110 1k
RV471 91 111 1k
RV472 92 112 1k
RV473 93 113 1k
RV474 94 114 1k
RV475 95 115 1k
RV476 96 116 1k
RV477 97 117 1k
RV478 98 118 1k
RV479 99 119 1k
RV480 100 120 1k
RV481 101 121 1k
RV482 102 122 1k
RV483 103 123 1k
RV484 104 124 1k
RV485 105 125 1k
RV486 106 126 1k
RV487 107 127 1k
RV488 108 128 1k
RV489 109 129 1k
RV490 110 130 1k
RV491 111 131 1k
RV492 112 132 1k
RV493 113 133 1k
RV494 114 134 1k
RV495 115 135 1k
RV496 116 136 1k
RV497 117 137 1k
RV498 118 138 1k
RV499 119 139 1k
RV500 120 140 1k
RV501 121 141 1k
RV502 122 142 1k
RV503 123 143 1k
RV504 124 144 1k
RV505 125 145 1k
RV506 126 146 1k
RV507 127 147 1k
RV508 128 148 1k
RV509 129 149 1k
RV510 130 150 1k
RV511 131 151 1k
RV512 132 152 1k
RV513 133 153 1k
RV514 134 154 1k
RV515 135 155 1k
RV516 136 156 1k
RV517 137 157 1k
RV518 138 158 1k
RV519 139 159 1k
RV520 140 160 1k
RV521 141 161 1k
RV522 142 162 1k
RV523 143 163 1k
RV524 144 164 1k
RV525 145 165 1k
RV526 146 166 1k
RV527 147 167 1k
RV528 148 168 1k
RV529 149 169 1k
RV530 150 170 1k
RV531 151 171 1k
RV532 152 172 1k
RV533 153 173 1k
RV534 154 174 1k
RV535 155 175 1k
RV536 156 176 1k
RV537 157 177 1k
RV538 158 178 1k
RV539 159 179 1k
RV540 160 180 1k
RV541 161 181 1k
RV542 162 182 1k
RV543 163 183 1k
RV544 164 184 1k
RV545 165 185 1k
RV546 166 186 1k
RV547 167 187 1k
RV548 168 188 1k
RV549 169 189 1k
RV550 170 190 1k
RV551 171 191 1k
RV552 172 192 1k
RV553 173 193 1k
RV554 174 194 1k
RV555 175 195 1k
RV556 176 196 1k
RV557 177 197 1k
RV558 178 198 1k
RV559 179 199 1k
RV560 180 200 1k
RV561 181 201 1k
RV562 182 202 1k
RV563 183 203 1k
RV564 184 204 1k
RV565 185 205 1k
RV566 186 206 1k
RV567 187 207 1k
RV568 188 208 1k
RV569 189 209 1k
RV570 190 210 1k
RV571 191 211 1k
RV572 192 212 1k
RV573 193 213 1k
RV574 194 214 1k
RV575 195 215 1k
RV576 196 216 1k
RV577 197 217 1k
RV578 198 218 1k
RV579 199 219 1k
RV580 200 220 1k
RV581 201 221 1k
RV582 202 222 1k
RV583 203 223 1k
RV584 204 224 1k
RV585 205 225 1k
RV586 206 226 1k
RV587 207 227 1k
RV588 208 228 1k
RV589 209 229 1k
RV590 210 230 1k
RV591 211 231 1k
RV592 212 232 1k
RV593 213 233 1k
RV594 214 234 1k
RV595 215 235 1k
RV596 216 236 1k
RV597 217 237 1k
RV598 218 238 1k
RV599 219 239 1k
RV600 220 240 1k
RV601 221 241 1k
RV602 222 242 1k
RV603 223 243 1k
RV604 224 244 1k
RV605 225 245 1k
RV606 226 246 1k
RV607 227 247 1k
RV608 228 248 1k
RV609 229 249 1k
RV610 230 250 1k
RV611 231 251 1k
RV612 232 252 1k
RV613 233 253 1k
RV614 234 254 1k
RV615 235 255 1k
RV616 236 256 1k
RV617 237 257 1k
RV618 238 258 1k
RV619 239 259 1k
RV620 240 260 1k
RV621 241 261 1k
RV622 242 262 1k
RV623 243 263 1k
RV624 244 264 1k
RV625 245 265 1k
RV626 246 266 1k
RV627 247 267 1k
RV628 248 268 1k
RV629 249 269 1k
RV630 250 270 1k
RV631 251 271 1k
RV632 252 272 1k
RV633 253 273 1k
RV634 254 274 1k
RV635 255 275 1k
RV636 256 276 1k
RV637 257 277 1k
RV638 258 278 1k
RV639 259 279 1k
RV640 260 280 1k
RV641 261 281 1k
RV642 262 282 1k
RV643 263 283 1k
RV644 264 284 1k
RV645 265 285 1k
RV646 266 286 1k
RV647 267 287 1k
RV648 268 288 1k
RV649 269 289 1k
RV650 270 290 1k
RV651 271 291 1k
RV652 272 292 1k
RV653 273 293 1k
RV654 274 294 1k
RV655 275 295 1k
RV656 276 296 1k
RV657 277 297 1k
RV658 278 298 1k
RV659 279 299 1k
RV660 280 300 1k
RV661 281 301 1k
RV662 282 302 1k
RV663 283 303 1k
RV664 284 304 1k
RV665 285 305 1k
RV666 286 306 1k
RV667 287 307 1k
RV668 288 308 1k
RV669 289 309 1k
RV670 290 310 1k
RV671 291 311 1k
RV672 292 312 1k
RV673 293 313 1k
RV674 294 314 1k
RV675 295 315 1k
RV676 296 316 1k
RV677 297 317 1k
RV678 298 318 1k
RV679 299 319 1k
RV680 300 320 1k
RV681 301 321 1k
RV682 302 322 1k
RV683 303 323 1k
RV684 304 324 1k
RV685 305 325 1k
RV686 306 326 1k
RV687 307 327 1k
RV688 308 328 1k
RV689 309 329 1k
RV690 310 330 1k
RV691 311 331 1k
RV692 312 332 1k
RV693 313 333 1k
RV694 314 334 1k
RV695 315 335 1k
RV696 316 336 1k
RV697 317 337 1k
RV698 318 338 1k
RV699 319 339 1k
RV700 320 340 1k
RV701 321 341 1k
RV702 322 342 1k
RV703 323 343 1k
RV704 324 344 1k
RV705 325 345 1k
RV706 326 346 1k
RV707 327 347 1k
RV708 328 348 1k
RV709 329 349 1k
RV710 330 350 1k
RV711 331 351 1k
RV712 332 352 1k
RV713 333 353 1k
RV714 334 354 1k
RV715 335 355 1k
RV716 336 356 1k
RV717 337 357 1k
RV718 338 358 1k
RV719 339 359 1k
RV720 340 360 1k
RV721 341 361 1k
RV722 342 362 1k
RV723 343 363 1k
RV724 344 364 1k
RV725 345 365 1k
RV726 346 366 1k
RV727 347 367 1k
RV728 348 368 1k
RV729 349 369 1k
RV730 350 370 1k
RV731 351 371 1k
RV732 352 372 1k
RV733 353 373 1k
RV734 354 374 1k
RV735 355 375 1k
RV736 356 376 1k
RV737 357 377 1k
RV738 358 378 1k
RV739 359 379 1k
RV740 360 380 1k
RV741 361 381 1k
RV742 362 382 1k
RV743 363 383 1k
RV744 364 384 1k
RV745 365 385 1k
RV746 366 386 1k
RV747 367 387 1k
RV748 368 388 1k
RV749 369 389 1k
RV750 370 390 1k
RV751 371 391 1k
RV752 372 392 1k
RV753 373 393 1k
RV754 374 394 1k
RV755 375 395 1k
RV756 376 396 1k
RV757 377 397 1k
RV758 378 398 1k
RV759 379 399 1k
RV760 380 400 1k
C1 1 0 1p
C2 2 0 1p
C3 3 0 1p
C4 4 0 1p
C5 5 0 1p
C6 6 0 1p
C7 7 0 1p
C8 8 0 1p
C9 9 0 1p
C10 10 0 1p
C11 11 0 1p
C12 12 0 1p
C13 13 0 1p
C14 14 0 1p
C15 15 0 1p
C16 16 0 1p
C17 17 0 1p
C18 18 0 1p
C19 19 0 1p
C20 20 0 1p
C21 21 0 1p
C22 22 0 1p
C23 23 0 1p
C24 24 0 1p
C25 25 0 1p
C26 26 0 1p
C27 27 0 1p
C28 28 0 1p
C29 29 0 1p
C30 30 0 1p
C31 31 0 1p
C32 32 0 1p
C33 33 0 1p
C34 34 0 1p
C35 35 0 1p
C36 36 0 1p
C37 37 0 1p
C38 38 0 1p
C39 39 0 1p
C40 40 0 1p
C41 41 0 1p
C42 42 0 1p
C43 43 0 1p
C44 44 0 1p
C45 45 0 1p
C46 46 0 1p
C47 47 0 1p
C48 48 0 1p
C49 49 0 1p
C50 50 0 1p
C51 51 0 1p
C52 52 0 1p
C53 53 0 1p
C54 54 0 1p
C55 55 0 1p
C56 56 0 1p
C57 57 0 1p
C58 58 0 1p
C59 59 0 1p
C60 60 0 1p
C61 61 0 1p
C62 62 0 1p
C63 63 0 1p
C64 64 0 1p
C65 65 0 1p
C66 66 0 1p
C67 67 0 1p
C68 68 0 1p
C69 69 0 1p
C70 70 0 1p
C71 71 0 1p
C72 72 0 1p
C73 73 0 1p
C74 74 0 1p
C75 75 0 1p
C76 76 0 1p
C77 77 0 1p
C78 78 0 1p
C79 79 0 1p
C80 80 0 1p
C81 81 0 1p
C82 82 0 1p
C83 83 0 1p
C84 84 0 1p
C85 85 0 1p
C86 86 0 1p
C87 87 0 1p
C88 88 0 1p
C89 89 0 1p
C90 90 0 1p
C91 91 0 1p
C92 92 0 1p
C93 93 0 1p
C94 94 0 1p
C95 95 0 1p
C96 96 0 1p
C97 97 0 1p
C98 98 0 1p
C99 99 0 1p
C100 100 0 1p
C101 101 0 1p
C102 102 0 1p
C103 103 0 1p
C104 104 0 1p
C105 105 0 1p
C106 106 0 1p
C107 107 0 1p
C108 108 0 1p
C109 109 0 1p
C110 110 0 1p
C111 111 0 1p
C112 112 0 1p
C113 113 0 1p
C114 114 0 1p
C115 115 0 1p
C116 116 0 1p
C117 117 0 1p
C118 118 0 1p
C119 119 0 1p
C120 120 0 1p
C121 121 0 1p
C122 122 0 1p
C123 123 0 1p
C124 124 0 1p
C125 125 0 1p
C126 126 0 1p
C127 127 0 1p
C128 128 0 1p
C129 129 0 1p
C130 130 0 1p
C131 131 0 1p
C132 132 0 1p
C133 133 0 1p
C134 134 0 1p
C135 135 0 1p
C136 136 0 1p
C137 137 0 1p
C138 138 0 1p
C139 139 0 1p
C140 140 0 1p
C141 141 0 1p
C142 142 0 1p
C143 143 0 1p
C144 144 0 1p
C145 145 0 1p
C146 146 0 1p
C147 147 0 1p
C148 148 0 1p
C149 149 0 1p
C150 150 0 1p
C151 151 0 1p
C152 152 0 1p
C153 153 0 1p
C154 154 0 1p
C155 155 0 1p
C156 156 0 1p
C157 157 0 1p
C158 158 0 1p
C159 159 0 1p
C160 160 0 1p
C161 161 0 1p
C162 162 0 1p
C163 163 0 1p
C164 164 0 1p
C165 165 0 1p
C166 166 0 1p
C167 167 0 1p
C168 168 0 1p
C169 169 0 1p
C170 170 0 1p
C171 171 0 1p
C172 172 0 1p
C173 173 0 1p
C174 174 0 1p
C175 175 0 1p
C176 176 0 1p
C177 177 0 1p
C178 178 0 1p
C179 179 0 1p
C180 180 0 1p
C181 181 0 1p
C182 182 0 1p
C183 183 0 1p
C184 184 0 1p
C185 185 0 1p
C186 186 0 1p
C187 187 0 1p
C188 188 0 1p
C189 189 0 1p
C190 190 0 1p
C191 191 0 1p
C192 192 0 1p
C193 193 0 1p
C194 194 0 1p
C195 195 0 1p
C196 196 0 1p
C197 197 0 1p
C198 198 0 1p
C199 199 0 1p
C200 200 0 1p
C201 201 0 1p
C202 202 0 1p
C203 203 0 1p
C204 204 0 1p
C205 205 0 1p
C206 206 0 1p
C207 207 0 1p
C208 208 0 1p
C209 209 0 1p
C210 210 0 1p
C211 211 0 1p
C212 212 0 1p
C213 213 0 1p
C214 214 0 1p
C215 215 0 1p
C216 216 0 1p
C217 217 0 1p
C218 218 0 1p
C219 219 0 1p
C220 220 0 1p
C221 221 0 1p
C222 222 0 1p
C223 223 0 1p
C224 224 0 1p
C225 225 0 1p
C226 226 0 1p
C227 227 0 1p
C228 228 0 1p
C229 229 0 1p
C230 230 0 1p
C231 231 0 1p
C232 232 0 1p
C233 233 0 1p
C234 234 0 1p
C235 235 0 1p
C236 236 0 1p
C237 237 0 1p
C238 238 0 1p
C239 239 0 1p
C240 240 0 1p
C241 241 0 1p
C242 242 0 1p
C243 243 0 1p
C244 244 0 1p
C245 245 0 1p
C246 246 0 1p
C247 247 0 1p
C248 248 0 1p
C249 249 0 1p
C250 250 0 1p
C251 251 0 1p
C252 252 0 1p
C253 253 0 1p
C254 254 0 1p
C255 255 0 1p
C256 256 0 1p
C257 257 0 1p
C258 258 0 1p
C259 259 0 1p
C260 260 0 1p
C261 261 0 1p
C262 262 0 1p
C263 263 0 1p
C264 264 0 1p
C265 265 0 1p
C266 266 0 1p
C267 267 0 1p
C268 268 0 1p
C269 269 0 1p
C270 270 0 1p
C271 271 0 1p
C272 272 0 1p
C273 273 0 1p
C274 274 0 1p
C275 275 0 1p
C276 276 0 1p
C277 277 0 1p
C278 278 0 1p
C279 279 0 1p
C280 280 0 1p
C281 281 0 1p
C282 282 0 1p
C283 283 0 1p
C284 284 0 1p
C285 285 0 1p
C286 286 0 1p
C287 287 0 1p
C288 288 0 1p
C289 289 0 1p
C290 290 0 1p
C291 291 0 1p
C292 292 0 1p
C293 293 0 1p
C294 294 0 1p
C295 295 0 1p
C296 296 0 1p
C297 297 0 1p
C298 298 0 1p
C299 299 0 1p
C300 300 0 1p
C301 301 0 1p
C302 302 0 1p
C303 303 0 1p
C304 304 0 1p
C305 305 0 1p
C306 306 0 1p
C307 307 0 1p
C308 308 0 1p
C309 309 0 1p
C310 310 0 1p
C311 311 0 1p
C312 312 0 1p
C313 313 0 1p
C314 314 0 1p
C315 315 0 1p
C316 316 0 1p
C317 317 0 1p
C318 318 0 1p
C319 319 0 1p
C320 320 0 1p
C321 321 0 1p
C322 322 0 1p
C323 323 0 1p
C324 324 0 1p
C325 325 0 1p
C326 326 0 1p
C327 327 0 1p
C328 328 0 1p
C329 329 0 1p
C330 330 0 1p
C331 331 0 1p
C332 332 0 1p
C333 333 0 1p
C334 334 0 1p
C335 335 0 1p
C336 336 0 1p
C337 337 0 1p
C338 338 0 1p
C339 339 0 1p
C340 340 0 1p
C341 341 0 1p
C342 342 0 1p
C343 343 0 1p
C344 344 0 1p
C345 345 0 1p
C346 346 0 1p
C347 347 0 1p
C348 348 0 1p
C349 349 0 1p
C350 350 0 1p
C351 351 0 1p
C352 352 0 1p
C353 353 0 1p
C354 354 0 1p
C355 355 0 1p
C356 356 0 1p
C357 357 0 1p
C358 358 0 1p
C359 359 0 1p
C360 360 0 1p
C361 361 0 1p
C362 362 0 1p
C363 363 0 1p
C364 364 0 1p
C365 365 0 1p
C366 366 0 1p
C367 367 0 1p
C368 368 0 1p
C369 369 0 1p
C370 370 0 1p
C371 371 0 1p
C372 372 0 1p
C373 373 0 1p
C374 374 0 1p
C375 375 0 1p
C376 376 0 1p
C377 377 0 1p
C378 378 0 1p
C379 379 0 1p
C380 380 0 1p
C381 381 0 1p
C382 382 0 1p
C383 383 0 1p
C384 384 0 1p
C385 385 0 1p
C386 386 0 1p
C387 387 0 1p
C388 388 0 1p
C389 389 0 1p
C390 390 0 1p
C391 391 0 1p
C392 392 0 1p
C393 393 0 1p
C394 394 0 1p
C395 395 0 1p
C396 396 0 1p
C397 397 0 1p
C398 398 0 1p
C399 399 0 1p
C400 400 0 1p
ROUT 400 0 1k
.TRAN 0.1n 1u
.END
