* Diode Ladder — 100 diodes in series
V1 in 0 DC 5

.MODEL DMOD D (IS=1e-14 N=1 BV=100 RS=10)

D1 in n1 DMOD
D2 n1 n2 DMOD
D3 n2 n3 DMOD
D4 n3 n4 DMOD
D5 n4 n5 DMOD
D6 n5 n6 DMOD
D7 n6 n7 DMOD
D8 n7 n8 DMOD
D9 n8 n9 DMOD
D10 n9 n10 DMOD
D11 n10 n11 DMOD
D12 n11 n12 DMOD
D13 n12 n13 DMOD
D14 n13 n14 DMOD
D15 n14 n15 DMOD
D16 n15 n16 DMOD
D17 n16 n17 DMOD
D18 n17 n18 DMOD
D19 n18 n19 DMOD
D20 n19 n20 DMOD
D21 n20 n21 DMOD
D22 n21 n22 DMOD
D23 n22 n23 DMOD
D24 n23 n24 DMOD
D25 n24 n25 DMOD
D26 n25 n26 DMOD
D27 n26 n27 DMOD
D28 n27 n28 DMOD
D29 n28 n29 DMOD
D30 n29 n30 DMOD
D31 n30 n31 DMOD
D32 n31 n32 DMOD
D33 n32 n33 DMOD
D34 n33 n34 DMOD
D35 n34 n35 DMOD
D36 n35 n36 DMOD
D37 n36 n37 DMOD
D38 n37 n38 DMOD
D39 n38 n39 DMOD
D40 n39 n40 DMOD
D41 n40 n41 DMOD
D42 n41 n42 DMOD
D43 n42 n43 DMOD
D44 n43 n44 DMOD
D45 n44 n45 DMOD
D46 n45 n46 DMOD
D47 n46 n47 DMOD
D48 n47 n48 DMOD
D49 n48 n49 DMOD
D50 n49 n50 DMOD
D51 n50 n51 DMOD
D52 n51 n52 DMOD
D53 n52 n53 DMOD
D54 n53 n54 DMOD
D55 n54 n55 DMOD
D56 n55 n56 DMOD
D57 n56 n57 DMOD
D58 n57 n58 DMOD
D59 n58 n59 DMOD
D60 n59 n60 DMOD
D61 n60 n61 DMOD
D62 n61 n62 DMOD
D63 n62 n63 DMOD
D64 n63 n64 DMOD
D65 n64 n65 DMOD
D66 n65 n66 DMOD
D67 n66 n67 DMOD
D68 n67 n68 DMOD
D69 n68 n69 DMOD
D70 n69 n70 DMOD
D71 n70 n71 DMOD
D72 n71 n72 DMOD
D73 n72 n73 DMOD
D74 n73 n74 DMOD
D75 n74 n75 DMOD
D76 n75 n76 DMOD
D77 n76 n77 DMOD
D78 n77 n78 DMOD
D79 n78 n79 DMOD
D80 n79 n80 DMOD
D81 n80 n81 DMOD
D82 n81 n82 DMOD
D83 n82 n83 DMOD
D84 n83 n84 DMOD
D85 n84 n85 DMOD
D86 n85 n86 DMOD
D87 n86 n87 DMOD
D88 n87 n88 DMOD
D89 n88 n89 DMOD
D90 n89 n90 DMOD
D91 n90 n91 DMOD
D92 n91 n92 DMOD
D93 n92 n93 DMOD
D94 n93 n94 DMOD
D95 n94 n95 DMOD
D96 n95 n96 DMOD
D97 n96 n97 DMOD
D98 n97 n98 DMOD
D99 n98 n99 DMOD
D100 n99 out DMOD

RLOAD out 0 1k

.OP
.DC V1 0 10 0.1
.END
