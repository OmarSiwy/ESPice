* RC Mesh — 10x10 grid
V1 1 0 PULSE(0 1 0 1n 1n 1u 2u)
RH1 1 2 1k
RH2 2 3 1k
RH3 3 4 1k
RH4 4 5 1k
RH5 5 6 1k
RH6 6 7 1k
RH7 7 8 1k
RH8 8 9 1k
RH9 9 10 1k
RH10 11 12 1k
RH11 12 13 1k
RH12 13 14 1k
RH13 14 15 1k
RH14 15 16 1k
RH15 16 17 1k
RH16 17 18 1k
RH17 18 19 1k
RH18 19 20 1k
RH19 21 22 1k
RH20 22 23 1k
RH21 23 24 1k
RH22 24 25 1k
RH23 25 26 1k
RH24 26 27 1k
RH25 27 28 1k
RH26 28 29 1k
RH27 29 30 1k
RH28 31 32 1k
RH29 32 33 1k
RH30 33 34 1k
RH31 34 35 1k
RH32 35 36 1k
RH33 36 37 1k
RH34 37 38 1k
RH35 38 39 1k
RH36 39 40 1k
RH37 41 42 1k
RH38 42 43 1k
RH39 43 44 1k
RH40 44 45 1k
RH41 45 46 1k
RH42 46 47 1k
RH43 47 48 1k
RH44 48 49 1k
RH45 49 50 1k
RH46 51 52 1k
RH47 52 53 1k
RH48 53 54 1k
RH49 54 55 1k
RH50 55 56 1k
RH51 56 57 1k
RH52 57 58 1k
RH53 58 59 1k
RH54 59 60 1k
RH55 61 62 1k
RH56 62 63 1k
RH57 63 64 1k
RH58 64 65 1k
RH59 65 66 1k
RH60 66 67 1k
RH61 67 68 1k
RH62 68 69 1k
RH63 69 70 1k
RH64 71 72 1k
RH65 72 73 1k
RH66 73 74 1k
RH67 74 75 1k
RH68 75 76 1k
RH69 76 77 1k
RH70 77 78 1k
RH71 78 79 1k
RH72 79 80 1k
RH73 81 82 1k
RH74 82 83 1k
RH75 83 84 1k
RH76 84 85 1k
RH77 85 86 1k
RH78 86 87 1k
RH79 87 88 1k
RH80 88 89 1k
RH81 89 90 1k
RH82 91 92 1k
RH83 92 93 1k
RH84 93 94 1k
RH85 94 95 1k
RH86 95 96 1k
RH87 96 97 1k
RH88 97 98 1k
RH89 98 99 1k
RH90 99 100 1k
RV91 1 11 1k
RV92 2 12 1k
RV93 3 13 1k
RV94 4 14 1k
RV95 5 15 1k
RV96 6 16 1k
RV97 7 17 1k
RV98 8 18 1k
RV99 9 19 1k
RV100 10 20 1k
RV101 11 21 1k
RV102 12 22 1k
RV103 13 23 1k
RV104 14 24 1k
RV105 15 25 1k
RV106 16 26 1k
RV107 17 27 1k
RV108 18 28 1k
RV109 19 29 1k
RV110 20 30 1k
RV111 21 31 1k
RV112 22 32 1k
RV113 23 33 1k
RV114 24 34 1k
RV115 25 35 1k
RV116 26 36 1k
RV117 27 37 1k
RV118 28 38 1k
RV119 29 39 1k
RV120 30 40 1k
RV121 31 41 1k
RV122 32 42 1k
RV123 33 43 1k
RV124 34 44 1k
RV125 35 45 1k
RV126 36 46 1k
RV127 37 47 1k
RV128 38 48 1k
RV129 39 49 1k
RV130 40 50 1k
RV131 41 51 1k
RV132 42 52 1k
RV133 43 53 1k
RV134 44 54 1k
RV135 45 55 1k
RV136 46 56 1k
RV137 47 57 1k
RV138 48 58 1k
RV139 49 59 1k
RV140 50 60 1k
RV141 51 61 1k
RV142 52 62 1k
RV143 53 63 1k
RV144 54 64 1k
RV145 55 65 1k
RV146 56 66 1k
RV147 57 67 1k
RV148 58 68 1k
RV149 59 69 1k
RV150 60 70 1k
RV151 61 71 1k
RV152 62 72 1k
RV153 63 73 1k
RV154 64 74 1k
RV155 65 75 1k
RV156 66 76 1k
RV157 67 77 1k
RV158 68 78 1k
RV159 69 79 1k
RV160 70 80 1k
RV161 71 81 1k
RV162 72 82 1k
RV163 73 83 1k
RV164 74 84 1k
RV165 75 85 1k
RV166 76 86 1k
RV167 77 87 1k
RV168 78 88 1k
RV169 79 89 1k
RV170 80 90 1k
RV171 81 91 1k
RV172 82 92 1k
RV173 83 93 1k
RV174 84 94 1k
RV175 85 95 1k
RV176 86 96 1k
RV177 87 97 1k
RV178 88 98 1k
RV179 89 99 1k
RV180 90 100 1k
C1 1 0 1p
C2 2 0 1p
C3 3 0 1p
C4 4 0 1p
C5 5 0 1p
C6 6 0 1p
C7 7 0 1p
C8 8 0 1p
C9 9 0 1p
C10 10 0 1p
C11 11 0 1p
C12 12 0 1p
C13 13 0 1p
C14 14 0 1p
C15 15 0 1p
C16 16 0 1p
C17 17 0 1p
C18 18 0 1p
C19 19 0 1p
C20 20 0 1p
C21 21 0 1p
C22 22 0 1p
C23 23 0 1p
C24 24 0 1p
C25 25 0 1p
C26 26 0 1p
C27 27 0 1p
C28 28 0 1p
C29 29 0 1p
C30 30 0 1p
C31 31 0 1p
C32 32 0 1p
C33 33 0 1p
C34 34 0 1p
C35 35 0 1p
C36 36 0 1p
C37 37 0 1p
C38 38 0 1p
C39 39 0 1p
C40 40 0 1p
C41 41 0 1p
C42 42 0 1p
C43 43 0 1p
C44 44 0 1p
C45 45 0 1p
C46 46 0 1p
C47 47 0 1p
C48 48 0 1p
C49 49 0 1p
C50 50 0 1p
C51 51 0 1p
C52 52 0 1p
C53 53 0 1p
C54 54 0 1p
C55 55 0 1p
C56 56 0 1p
C57 57 0 1p
C58 58 0 1p
C59 59 0 1p
C60 60 0 1p
C61 61 0 1p
C62 62 0 1p
C63 63 0 1p
C64 64 0 1p
C65 65 0 1p
C66 66 0 1p
C67 67 0 1p
C68 68 0 1p
C69 69 0 1p
C70 70 0 1p
C71 71 0 1p
C72 72 0 1p
C73 73 0 1p
C74 74 0 1p
C75 75 0 1p
C76 76 0 1p
C77 77 0 1p
C78 78 0 1p
C79 79 0 1p
C80 80 0 1p
C81 81 0 1p
C82 82 0 1p
C83 83 0 1p
C84 84 0 1p
C85 85 0 1p
C86 86 0 1p
C87 87 0 1p
C88 88 0 1p
C89 89 0 1p
C90 90 0 1p
C91 91 0 1p
C92 92 0 1p
C93 93 0 1p
C94 94 0 1p
C95 95 0 1p
C96 96 0 1p
C97 97 0 1p
C98 98 0 1p
C99 99 0 1p
C100 100 0 1p
ROUT 100 0 1k
.TRAN 0.1n 1u
.END
