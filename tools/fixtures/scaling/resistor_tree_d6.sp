* Resistor Binary Tree — depth 6 (127 nodes)
V1 n1 0 DC 1

R1 n1 n2 1k
R2 n1 n3 1k
R3 n2 n4 1k
R4 n2 n5 1k
R5 n3 n6 1k
R6 n3 n7 1k
R7 n4 n8 1k
R8 n4 n9 1k
R9 n5 n10 1k
R10 n5 n11 1k
R11 n6 n12 1k
R12 n6 n13 1k
R13 n7 n14 1k
R14 n7 n15 1k
R15 n8 n16 1k
R16 n8 n17 1k
R17 n9 n18 1k
R18 n9 n19 1k
R19 n10 n20 1k
R20 n10 n21 1k
R21 n11 n22 1k
R22 n11 n23 1k
R23 n12 n24 1k
R24 n12 n25 1k
R25 n13 n26 1k
R26 n13 n27 1k
R27 n14 n28 1k
R28 n14 n29 1k
R29 n15 n30 1k
R30 n15 n31 1k
R31 n16 n32 1k
R32 n16 n33 1k
R33 n17 n34 1k
R34 n17 n35 1k
R35 n18 n36 1k
R36 n18 n37 1k
R37 n19 n38 1k
R38 n19 n39 1k
R39 n20 n40 1k
R40 n20 n41 1k
R41 n21 n42 1k
R42 n21 n43 1k
R43 n22 n44 1k
R44 n22 n45 1k
R45 n23 n46 1k
R46 n23 n47 1k
R47 n24 n48 1k
R48 n24 n49 1k
R49 n25 n50 1k
R50 n25 n51 1k
R51 n26 n52 1k
R52 n26 n53 1k
R53 n27 n54 1k
R54 n27 n55 1k
R55 n28 n56 1k
R56 n28 n57 1k
R57 n29 n58 1k
R58 n29 n59 1k
R59 n30 n60 1k
R60 n30 n61 1k
R61 n31 n62 1k
R62 n31 n63 1k
R63 n32 n64 1k
R64 n32 n65 1k
R65 n33 n66 1k
R66 n33 n67 1k
R67 n34 n68 1k
R68 n34 n69 1k
R69 n35 n70 1k
R70 n35 n71 1k
R71 n36 n72 1k
R72 n36 n73 1k
R73 n37 n74 1k
R74 n37 n75 1k
R75 n38 n76 1k
R76 n38 n77 1k
R77 n39 n78 1k
R78 n39 n79 1k
R79 n40 n80 1k
R80 n40 n81 1k
R81 n41 n82 1k
R82 n41 n83 1k
R83 n42 n84 1k
R84 n42 n85 1k
R85 n43 n86 1k
R86 n43 n87 1k
R87 n44 n88 1k
R88 n44 n89 1k
R89 n45 n90 1k
R90 n45 n91 1k
R91 n46 n92 1k
R92 n46 n93 1k
R93 n47 n94 1k
R94 n47 n95 1k
R95 n48 n96 1k
R96 n48 n97 1k
R97 n49 n98 1k
R98 n49 n99 1k
R99 n50 n100 1k
R100 n50 n101 1k
R101 n51 n102 1k
R102 n51 n103 1k
R103 n52 n104 1k
R104 n52 n105 1k
R105 n53 n106 1k
R106 n53 n107 1k
R107 n54 n108 1k
R108 n54 n109 1k
R109 n55 n110 1k
R110 n55 n111 1k
R111 n56 n112 1k
R112 n56 n113 1k
R113 n57 n114 1k
R114 n57 n115 1k
R115 n58 n116 1k
R116 n58 n117 1k
R117 n59 n118 1k
R118 n59 n119 1k
R119 n60 n120 1k
R120 n60 n121 1k
R121 n61 n122 1k
R122 n61 n123 1k
R123 n62 n124 1k
R124 n62 n125 1k
R125 n63 n126 1k
R126 n63 n127 1k
R127 n64 0 1k
R128 n65 0 1k
R129 n66 0 1k
R130 n67 0 1k
R131 n68 0 1k
R132 n69 0 1k
R133 n70 0 1k
R134 n71 0 1k
R135 n72 0 1k
R136 n73 0 1k
R137 n74 0 1k
R138 n75 0 1k
R139 n76 0 1k
R140 n77 0 1k
R141 n78 0 1k
R142 n79 0 1k
R143 n80 0 1k
R144 n81 0 1k
R145 n82 0 1k
R146 n83 0 1k
R147 n84 0 1k
R148 n85 0 1k
R149 n86 0 1k
R150 n87 0 1k
R151 n88 0 1k
R152 n89 0 1k
R153 n90 0 1k
R154 n91 0 1k
R155 n92 0 1k
R156 n93 0 1k
R157 n94 0 1k
R158 n95 0 1k
R159 n96 0 1k
R160 n97 0 1k
R161 n98 0 1k
R162 n99 0 1k
R163 n100 0 1k
R164 n101 0 1k
R165 n102 0 1k
R166 n103 0 1k
R167 n104 0 1k
R168 n105 0 1k
R169 n106 0 1k
R170 n107 0 1k
R171 n108 0 1k
R172 n109 0 1k
R173 n110 0 1k
R174 n111 0 1k
R175 n112 0 1k
R176 n113 0 1k
R177 n114 0 1k
R178 n115 0 1k
R179 n116 0 1k
R180 n117 0 1k
R181 n118 0 1k
R182 n119 0 1k
R183 n120 0 1k
R184 n121 0 1k
R185 n122 0 1k
R186 n123 0 1k
R187 n124 0 1k
R188 n125 0 1k
R189 n126 0 1k
R190 n127 0 1k

.OP
.END
