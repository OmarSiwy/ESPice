* RC Ladder — 10 stages
V1 1 0 PULSE(0 1 0 1n 1n 1u 2u)
R1 1 2 1k
R2 2 3 1k
R3 3 4 1k
R4 4 5 1k
R5 5 6 1k
R6 6 7 1k
R7 7 8 1k
R8 8 9 1k
R9 9 10 1k
R10 10 11 1k
C1 2 0 1p
C2 3 0 1p
C3 4 0 1p
C4 5 0 1p
C5 6 0 1p
C6 7 0 1p
C7 8 0 1p
C8 9 0 1p
C9 10 0 1p
C10 11 0 1p
.TRAN 0.1n 10u
.END
