* Resistor Star Network — 10 branches
V1 center 0 DC 1

R1 center node_1 1k
R2 center node_2 1k
R3 center node_3 1k
R4 center node_4 1k
R5 center node_5 1k
R6 center node_6 1k
R7 center node_7 1k
R8 center node_8 1k
R9 center node_9 1k
R10 center node_10 1k
RG1 node_1 0 1k
RG2 node_2 0 1k
RG3 node_3 0 1k
RG4 node_4 0 1k
RG5 node_5 0 1k
RG6 node_6 0 1k
RG7 node_7 0 1k
RG8 node_8 0 1k
RG9 node_9 0 1k
RG10 node_10 0 1k

.OP
.END
