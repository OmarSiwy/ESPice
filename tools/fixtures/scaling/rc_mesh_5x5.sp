* RC Mesh — 5x5 grid
V1 1 0 PULSE(0 1 0 1n 1n 1u 2u)
RH1 1 2 1k
RH2 2 3 1k
RH3 3 4 1k
RH4 4 5 1k
RH5 6 7 1k
RH6 7 8 1k
RH7 8 9 1k
RH8 9 10 1k
RH9 11 12 1k
RH10 12 13 1k
RH11 13 14 1k
RH12 14 15 1k
RH13 16 17 1k
RH14 17 18 1k
RH15 18 19 1k
RH16 19 20 1k
RH17 21 22 1k
RH18 22 23 1k
RH19 23 24 1k
RH20 24 25 1k
RV21 1 6 1k
RV22 2 7 1k
RV23 3 8 1k
RV24 4 9 1k
RV25 5 10 1k
RV26 6 11 1k
RV27 7 12 1k
RV28 8 13 1k
RV29 9 14 1k
RV30 10 15 1k
RV31 11 16 1k
RV32 12 17 1k
RV33 13 18 1k
RV34 14 19 1k
RV35 15 20 1k
RV36 16 21 1k
RV37 17 22 1k
RV38 18 23 1k
RV39 19 24 1k
RV40 20 25 1k
C1 1 0 1p
C2 2 0 1p
C3 3 0 1p
C4 4 0 1p
C5 5 0 1p
C6 6 0 1p
C7 7 0 1p
C8 8 0 1p
C9 9 0 1p
C10 10 0 1p
C11 11 0 1p
C12 12 0 1p
C13 13 0 1p
C14 14 0 1p
C15 15 0 1p
C16 16 0 1p
C17 17 0 1p
C18 18 0 1p
C19 19 0 1p
C20 20 0 1p
C21 21 0 1p
C22 22 0 1p
C23 23 0 1p
C24 24 0 1p
C25 25 0 1p
ROUT 25 0 1k
.TRAN 0.1n 1u
.END
