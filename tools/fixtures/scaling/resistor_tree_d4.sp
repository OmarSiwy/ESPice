* Resistor Binary Tree — depth 4 (31 nodes)
V1 n1 0 DC 1

R1 n1 n2 1k
R2 n1 n3 1k
R3 n2 n4 1k
R4 n2 n5 1k
R5 n3 n6 1k
R6 n3 n7 1k
R7 n4 n8 1k
R8 n4 n9 1k
R9 n5 n10 1k
R10 n5 n11 1k
R11 n6 n12 1k
R12 n6 n13 1k
R13 n7 n14 1k
R14 n7 n15 1k
R15 n8 n16 1k
R16 n8 n17 1k
R17 n9 n18 1k
R18 n9 n19 1k
R19 n10 n20 1k
R20 n10 n21 1k
R21 n11 n22 1k
R22 n11 n23 1k
R23 n12 n24 1k
R24 n12 n25 1k
R25 n13 n26 1k
R26 n13 n27 1k
R27 n14 n28 1k
R28 n14 n29 1k
R29 n15 n30 1k
R30 n15 n31 1k
R31 n16 0 1k
R32 n17 0 1k
R33 n18 0 1k
R34 n19 0 1k
R35 n20 0 1k
R36 n21 0 1k
R37 n22 0 1k
R38 n23 0 1k
R39 n24 0 1k
R40 n25 0 1k
R41 n26 0 1k
R42 n27 0 1k
R43 n28 0 1k
R44 n29 0 1k
R45 n30 0 1k
R46 n31 0 1k

.OP
.END
