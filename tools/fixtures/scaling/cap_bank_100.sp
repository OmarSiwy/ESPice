* Capacitor Bank — 100 parallel caps
V1 in 0 PULSE(0 5 0 1n 1n 1u 2u)
RS in bus 10

C1 bus 0 1p
C2 bus 0 1p
C3 bus 0 1p
C4 bus 0 1p
C5 bus 0 1p
C6 bus 0 1p
C7 bus 0 1p
C8 bus 0 1p
C9 bus 0 1p
C10 bus 0 1p
C11 bus 0 1p
C12 bus 0 1p
C13 bus 0 1p
C14 bus 0 1p
C15 bus 0 1p
C16 bus 0 1p
C17 bus 0 1p
C18 bus 0 1p
C19 bus 0 1p
C20 bus 0 1p
C21 bus 0 1p
C22 bus 0 1p
C23 bus 0 1p
C24 bus 0 1p
C25 bus 0 1p
C26 bus 0 1p
C27 bus 0 1p
C28 bus 0 1p
C29 bus 0 1p
C30 bus 0 1p
C31 bus 0 1p
C32 bus 0 1p
C33 bus 0 1p
C34 bus 0 1p
C35 bus 0 1p
C36 bus 0 1p
C37 bus 0 1p
C38 bus 0 1p
C39 bus 0 1p
C40 bus 0 1p
C41 bus 0 1p
C42 bus 0 1p
C43 bus 0 1p
C44 bus 0 1p
C45 bus 0 1p
C46 bus 0 1p
C47 bus 0 1p
C48 bus 0 1p
C49 bus 0 1p
C50 bus 0 1p
C51 bus 0 1p
C52 bus 0 1p
C53 bus 0 1p
C54 bus 0 1p
C55 bus 0 1p
C56 bus 0 1p
C57 bus 0 1p
C58 bus 0 1p
C59 bus 0 1p
C60 bus 0 1p
C61 bus 0 1p
C62 bus 0 1p
C63 bus 0 1p
C64 bus 0 1p
C65 bus 0 1p
C66 bus 0 1p
C67 bus 0 1p
C68 bus 0 1p
C69 bus 0 1p
C70 bus 0 1p
C71 bus 0 1p
C72 bus 0 1p
C73 bus 0 1p
C74 bus 0 1p
C75 bus 0 1p
C76 bus 0 1p
C77 bus 0 1p
C78 bus 0 1p
C79 bus 0 1p
C80 bus 0 1p
C81 bus 0 1p
C82 bus 0 1p
C83 bus 0 1p
C84 bus 0 1p
C85 bus 0 1p
C86 bus 0 1p
C87 bus 0 1p
C88 bus 0 1p
C89 bus 0 1p
C90 bus 0 1p
C91 bus 0 1p
C92 bus 0 1p
C93 bus 0 1p
C94 bus 0 1p
C95 bus 0 1p
C96 bus 0 1p
C97 bus 0 1p
C98 bus 0 1p
C99 bus 0 1p
C100 bus 0 1p
RL1 bus 0 1MEG
RL2 bus 0 1MEG
RL3 bus 0 1MEG
RL4 bus 0 1MEG
RL5 bus 0 1MEG
RL6 bus 0 1MEG
RL7 bus 0 1MEG
RL8 bus 0 1MEG
RL9 bus 0 1MEG
RL10 bus 0 1MEG
RL11 bus 0 1MEG
RL12 bus 0 1MEG
RL13 bus 0 1MEG
RL14 bus 0 1MEG
RL15 bus 0 1MEG
RL16 bus 0 1MEG
RL17 bus 0 1MEG
RL18 bus 0 1MEG
RL19 bus 0 1MEG
RL20 bus 0 1MEG
RL21 bus 0 1MEG
RL22 bus 0 1MEG
RL23 bus 0 1MEG
RL24 bus 0 1MEG
RL25 bus 0 1MEG
RL26 bus 0 1MEG
RL27 bus 0 1MEG
RL28 bus 0 1MEG
RL29 bus 0 1MEG
RL30 bus 0 1MEG
RL31 bus 0 1MEG
RL32 bus 0 1MEG
RL33 bus 0 1MEG
RL34 bus 0 1MEG
RL35 bus 0 1MEG
RL36 bus 0 1MEG
RL37 bus 0 1MEG
RL38 bus 0 1MEG
RL39 bus 0 1MEG
RL40 bus 0 1MEG
RL41 bus 0 1MEG
RL42 bus 0 1MEG
RL43 bus 0 1MEG
RL44 bus 0 1MEG
RL45 bus 0 1MEG
RL46 bus 0 1MEG
RL47 bus 0 1MEG
RL48 bus 0 1MEG
RL49 bus 0 1MEG
RL50 bus 0 1MEG
RL51 bus 0 1MEG
RL52 bus 0 1MEG
RL53 bus 0 1MEG
RL54 bus 0 1MEG
RL55 bus 0 1MEG
RL56 bus 0 1MEG
RL57 bus 0 1MEG
RL58 bus 0 1MEG
RL59 bus 0 1MEG
RL60 bus 0 1MEG
RL61 bus 0 1MEG
RL62 bus 0 1MEG
RL63 bus 0 1MEG
RL64 bus 0 1MEG
RL65 bus 0 1MEG
RL66 bus 0 1MEG
RL67 bus 0 1MEG
RL68 bus 0 1MEG
RL69 bus 0 1MEG
RL70 bus 0 1MEG
RL71 bus 0 1MEG
RL72 bus 0 1MEG
RL73 bus 0 1MEG
RL74 bus 0 1MEG
RL75 bus 0 1MEG
RL76 bus 0 1MEG
RL77 bus 0 1MEG
RL78 bus 0 1MEG
RL79 bus 0 1MEG
RL80 bus 0 1MEG
RL81 bus 0 1MEG
RL82 bus 0 1MEG
RL83 bus 0 1MEG
RL84 bus 0 1MEG
RL85 bus 0 1MEG
RL86 bus 0 1MEG
RL87 bus 0 1MEG
RL88 bus 0 1MEG
RL89 bus 0 1MEG
RL90 bus 0 1MEG
RL91 bus 0 1MEG
RL92 bus 0 1MEG
RL93 bus 0 1MEG
RL94 bus 0 1MEG
RL95 bus 0 1MEG
RL96 bus 0 1MEG
RL97 bus 0 1MEG
RL98 bus 0 1MEG
RL99 bus 0 1MEG
RL100 bus 0 1MEG

.TRAN 0.1n 5u
.END
