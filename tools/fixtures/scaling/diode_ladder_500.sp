* Diode Ladder — 500 diodes in series
V1 in 0 DC 5

.MODEL DMOD D (IS=1e-14 N=1 BV=100 RS=10)

D1 in n1 DMOD
D2 n1 n2 DMOD
D3 n2 n3 DMOD
D4 n3 n4 DMOD
D5 n4 n5 DMOD
D6 n5 n6 DMOD
D7 n6 n7 DMOD
D8 n7 n8 DMOD
D9 n8 n9 DMOD
D10 n9 n10 DMOD
D11 n10 n11 DMOD
D12 n11 n12 DMOD
D13 n12 n13 DMOD
D14 n13 n14 DMOD
D15 n14 n15 DMOD
D16 n15 n16 DMOD
D17 n16 n17 DMOD
D18 n17 n18 DMOD
D19 n18 n19 DMOD
D20 n19 n20 DMOD
D21 n20 n21 DMOD
D22 n21 n22 DMOD
D23 n22 n23 DMOD
D24 n23 n24 DMOD
D25 n24 n25 DMOD
D26 n25 n26 DMOD
D27 n26 n27 DMOD
D28 n27 n28 DMOD
D29 n28 n29 DMOD
D30 n29 n30 DMOD
D31 n30 n31 DMOD
D32 n31 n32 DMOD
D33 n32 n33 DMOD
D34 n33 n34 DMOD
D35 n34 n35 DMOD
D36 n35 n36 DMOD
D37 n36 n37 DMOD
D38 n37 n38 DMOD
D39 n38 n39 DMOD
D40 n39 n40 DMOD
D41 n40 n41 DMOD
D42 n41 n42 DMOD
D43 n42 n43 DMOD
D44 n43 n44 DMOD
D45 n44 n45 DMOD
D46 n45 n46 DMOD
D47 n46 n47 DMOD
D48 n47 n48 DMOD
D49 n48 n49 DMOD
D50 n49 n50 DMOD
D51 n50 n51 DMOD
D52 n51 n52 DMOD
D53 n52 n53 DMOD
D54 n53 n54 DMOD
D55 n54 n55 DMOD
D56 n55 n56 DMOD
D57 n56 n57 DMOD
D58 n57 n58 DMOD
D59 n58 n59 DMOD
D60 n59 n60 DMOD
D61 n60 n61 DMOD
D62 n61 n62 DMOD
D63 n62 n63 DMOD
D64 n63 n64 DMOD
D65 n64 n65 DMOD
D66 n65 n66 DMOD
D67 n66 n67 DMOD
D68 n67 n68 DMOD
D69 n68 n69 DMOD
D70 n69 n70 DMOD
D71 n70 n71 DMOD
D72 n71 n72 DMOD
D73 n72 n73 DMOD
D74 n73 n74 DMOD
D75 n74 n75 DMOD
D76 n75 n76 DMOD
D77 n76 n77 DMOD
D78 n77 n78 DMOD
D79 n78 n79 DMOD
D80 n79 n80 DMOD
D81 n80 n81 DMOD
D82 n81 n82 DMOD
D83 n82 n83 DMOD
D84 n83 n84 DMOD
D85 n84 n85 DMOD
D86 n85 n86 DMOD
D87 n86 n87 DMOD
D88 n87 n88 DMOD
D89 n88 n89 DMOD
D90 n89 n90 DMOD
D91 n90 n91 DMOD
D92 n91 n92 DMOD
D93 n92 n93 DMOD
D94 n93 n94 DMOD
D95 n94 n95 DMOD
D96 n95 n96 DMOD
D97 n96 n97 DMOD
D98 n97 n98 DMOD
D99 n98 n99 DMOD
D100 n99 n100 DMOD
D101 n100 n101 DMOD
D102 n101 n102 DMOD
D103 n102 n103 DMOD
D104 n103 n104 DMOD
D105 n104 n105 DMOD
D106 n105 n106 DMOD
D107 n106 n107 DMOD
D108 n107 n108 DMOD
D109 n108 n109 DMOD
D110 n109 n110 DMOD
D111 n110 n111 DMOD
D112 n111 n112 DMOD
D113 n112 n113 DMOD
D114 n113 n114 DMOD
D115 n114 n115 DMOD
D116 n115 n116 DMOD
D117 n116 n117 DMOD
D118 n117 n118 DMOD
D119 n118 n119 DMOD
D120 n119 n120 DMOD
D121 n120 n121 DMOD
D122 n121 n122 DMOD
D123 n122 n123 DMOD
D124 n123 n124 DMOD
D125 n124 n125 DMOD
D126 n125 n126 DMOD
D127 n126 n127 DMOD
D128 n127 n128 DMOD
D129 n128 n129 DMOD
D130 n129 n130 DMOD
D131 n130 n131 DMOD
D132 n131 n132 DMOD
D133 n132 n133 DMOD
D134 n133 n134 DMOD
D135 n134 n135 DMOD
D136 n135 n136 DMOD
D137 n136 n137 DMOD
D138 n137 n138 DMOD
D139 n138 n139 DMOD
D140 n139 n140 DMOD
D141 n140 n141 DMOD
D142 n141 n142 DMOD
D143 n142 n143 DMOD
D144 n143 n144 DMOD
D145 n144 n145 DMOD
D146 n145 n146 DMOD
D147 n146 n147 DMOD
D148 n147 n148 DMOD
D149 n148 n149 DMOD
D150 n149 n150 DMOD
D151 n150 n151 DMOD
D152 n151 n152 DMOD
D153 n152 n153 DMOD
D154 n153 n154 DMOD
D155 n154 n155 DMOD
D156 n155 n156 DMOD
D157 n156 n157 DMOD
D158 n157 n158 DMOD
D159 n158 n159 DMOD
D160 n159 n160 DMOD
D161 n160 n161 DMOD
D162 n161 n162 DMOD
D163 n162 n163 DMOD
D164 n163 n164 DMOD
D165 n164 n165 DMOD
D166 n165 n166 DMOD
D167 n166 n167 DMOD
D168 n167 n168 DMOD
D169 n168 n169 DMOD
D170 n169 n170 DMOD
D171 n170 n171 DMOD
D172 n171 n172 DMOD
D173 n172 n173 DMOD
D174 n173 n174 DMOD
D175 n174 n175 DMOD
D176 n175 n176 DMOD
D177 n176 n177 DMOD
D178 n177 n178 DMOD
D179 n178 n179 DMOD
D180 n179 n180 DMOD
D181 n180 n181 DMOD
D182 n181 n182 DMOD
D183 n182 n183 DMOD
D184 n183 n184 DMOD
D185 n184 n185 DMOD
D186 n185 n186 DMOD
D187 n186 n187 DMOD
D188 n187 n188 DMOD
D189 n188 n189 DMOD
D190 n189 n190 DMOD
D191 n190 n191 DMOD
D192 n191 n192 DMOD
D193 n192 n193 DMOD
D194 n193 n194 DMOD
D195 n194 n195 DMOD
D196 n195 n196 DMOD
D197 n196 n197 DMOD
D198 n197 n198 DMOD
D199 n198 n199 DMOD
D200 n199 n200 DMOD
D201 n200 n201 DMOD
D202 n201 n202 DMOD
D203 n202 n203 DMOD
D204 n203 n204 DMOD
D205 n204 n205 DMOD
D206 n205 n206 DMOD
D207 n206 n207 DMOD
D208 n207 n208 DMOD
D209 n208 n209 DMOD
D210 n209 n210 DMOD
D211 n210 n211 DMOD
D212 n211 n212 DMOD
D213 n212 n213 DMOD
D214 n213 n214 DMOD
D215 n214 n215 DMOD
D216 n215 n216 DMOD
D217 n216 n217 DMOD
D218 n217 n218 DMOD
D219 n218 n219 DMOD
D220 n219 n220 DMOD
D221 n220 n221 DMOD
D222 n221 n222 DMOD
D223 n222 n223 DMOD
D224 n223 n224 DMOD
D225 n224 n225 DMOD
D226 n225 n226 DMOD
D227 n226 n227 DMOD
D228 n227 n228 DMOD
D229 n228 n229 DMOD
D230 n229 n230 DMOD
D231 n230 n231 DMOD
D232 n231 n232 DMOD
D233 n232 n233 DMOD
D234 n233 n234 DMOD
D235 n234 n235 DMOD
D236 n235 n236 DMOD
D237 n236 n237 DMOD
D238 n237 n238 DMOD
D239 n238 n239 DMOD
D240 n239 n240 DMOD
D241 n240 n241 DMOD
D242 n241 n242 DMOD
D243 n242 n243 DMOD
D244 n243 n244 DMOD
D245 n244 n245 DMOD
D246 n245 n246 DMOD
D247 n246 n247 DMOD
D248 n247 n248 DMOD
D249 n248 n249 DMOD
D250 n249 n250 DMOD
D251 n250 n251 DMOD
D252 n251 n252 DMOD
D253 n252 n253 DMOD
D254 n253 n254 DMOD
D255 n254 n255 DMOD
D256 n255 n256 DMOD
D257 n256 n257 DMOD
D258 n257 n258 DMOD
D259 n258 n259 DMOD
D260 n259 n260 DMOD
D261 n260 n261 DMOD
D262 n261 n262 DMOD
D263 n262 n263 DMOD
D264 n263 n264 DMOD
D265 n264 n265 DMOD
D266 n265 n266 DMOD
D267 n266 n267 DMOD
D268 n267 n268 DMOD
D269 n268 n269 DMOD
D270 n269 n270 DMOD
D271 n270 n271 DMOD
D272 n271 n272 DMOD
D273 n272 n273 DMOD
D274 n273 n274 DMOD
D275 n274 n275 DMOD
D276 n275 n276 DMOD
D277 n276 n277 DMOD
D278 n277 n278 DMOD
D279 n278 n279 DMOD
D280 n279 n280 DMOD
D281 n280 n281 DMOD
D282 n281 n282 DMOD
D283 n282 n283 DMOD
D284 n283 n284 DMOD
D285 n284 n285 DMOD
D286 n285 n286 DMOD
D287 n286 n287 DMOD
D288 n287 n288 DMOD
D289 n288 n289 DMOD
D290 n289 n290 DMOD
D291 n290 n291 DMOD
D292 n291 n292 DMOD
D293 n292 n293 DMOD
D294 n293 n294 DMOD
D295 n294 n295 DMOD
D296 n295 n296 DMOD
D297 n296 n297 DMOD
D298 n297 n298 DMOD
D299 n298 n299 DMOD
D300 n299 n300 DMOD
D301 n300 n301 DMOD
D302 n301 n302 DMOD
D303 n302 n303 DMOD
D304 n303 n304 DMOD
D305 n304 n305 DMOD
D306 n305 n306 DMOD
D307 n306 n307 DMOD
D308 n307 n308 DMOD
D309 n308 n309 DMOD
D310 n309 n310 DMOD
D311 n310 n311 DMOD
D312 n311 n312 DMOD
D313 n312 n313 DMOD
D314 n313 n314 DMOD
D315 n314 n315 DMOD
D316 n315 n316 DMOD
D317 n316 n317 DMOD
D318 n317 n318 DMOD
D319 n318 n319 DMOD
D320 n319 n320 DMOD
D321 n320 n321 DMOD
D322 n321 n322 DMOD
D323 n322 n323 DMOD
D324 n323 n324 DMOD
D325 n324 n325 DMOD
D326 n325 n326 DMOD
D327 n326 n327 DMOD
D328 n327 n328 DMOD
D329 n328 n329 DMOD
D330 n329 n330 DMOD
D331 n330 n331 DMOD
D332 n331 n332 DMOD
D333 n332 n333 DMOD
D334 n333 n334 DMOD
D335 n334 n335 DMOD
D336 n335 n336 DMOD
D337 n336 n337 DMOD
D338 n337 n338 DMOD
D339 n338 n339 DMOD
D340 n339 n340 DMOD
D341 n340 n341 DMOD
D342 n341 n342 DMOD
D343 n342 n343 DMOD
D344 n343 n344 DMOD
D345 n344 n345 DMOD
D346 n345 n346 DMOD
D347 n346 n347 DMOD
D348 n347 n348 DMOD
D349 n348 n349 DMOD
D350 n349 n350 DMOD
D351 n350 n351 DMOD
D352 n351 n352 DMOD
D353 n352 n353 DMOD
D354 n353 n354 DMOD
D355 n354 n355 DMOD
D356 n355 n356 DMOD
D357 n356 n357 DMOD
D358 n357 n358 DMOD
D359 n358 n359 DMOD
D360 n359 n360 DMOD
D361 n360 n361 DMOD
D362 n361 n362 DMOD
D363 n362 n363 DMOD
D364 n363 n364 DMOD
D365 n364 n365 DMOD
D366 n365 n366 DMOD
D367 n366 n367 DMOD
D368 n367 n368 DMOD
D369 n368 n369 DMOD
D370 n369 n370 DMOD
D371 n370 n371 DMOD
D372 n371 n372 DMOD
D373 n372 n373 DMOD
D374 n373 n374 DMOD
D375 n374 n375 DMOD
D376 n375 n376 DMOD
D377 n376 n377 DMOD
D378 n377 n378 DMOD
D379 n378 n379 DMOD
D380 n379 n380 DMOD
D381 n380 n381 DMOD
D382 n381 n382 DMOD
D383 n382 n383 DMOD
D384 n383 n384 DMOD
D385 n384 n385 DMOD
D386 n385 n386 DMOD
D387 n386 n387 DMOD
D388 n387 n388 DMOD
D389 n388 n389 DMOD
D390 n389 n390 DMOD
D391 n390 n391 DMOD
D392 n391 n392 DMOD
D393 n392 n393 DMOD
D394 n393 n394 DMOD
D395 n394 n395 DMOD
D396 n395 n396 DMOD
D397 n396 n397 DMOD
D398 n397 n398 DMOD
D399 n398 n399 DMOD
D400 n399 n400 DMOD
D401 n400 n401 DMOD
D402 n401 n402 DMOD
D403 n402 n403 DMOD
D404 n403 n404 DMOD
D405 n404 n405 DMOD
D406 n405 n406 DMOD
D407 n406 n407 DMOD
D408 n407 n408 DMOD
D409 n408 n409 DMOD
D410 n409 n410 DMOD
D411 n410 n411 DMOD
D412 n411 n412 DMOD
D413 n412 n413 DMOD
D414 n413 n414 DMOD
D415 n414 n415 DMOD
D416 n415 n416 DMOD
D417 n416 n417 DMOD
D418 n417 n418 DMOD
D419 n418 n419 DMOD
D420 n419 n420 DMOD
D421 n420 n421 DMOD
D422 n421 n422 DMOD
D423 n422 n423 DMOD
D424 n423 n424 DMOD
D425 n424 n425 DMOD
D426 n425 n426 DMOD
D427 n426 n427 DMOD
D428 n427 n428 DMOD
D429 n428 n429 DMOD
D430 n429 n430 DMOD
D431 n430 n431 DMOD
D432 n431 n432 DMOD
D433 n432 n433 DMOD
D434 n433 n434 DMOD
D435 n434 n435 DMOD
D436 n435 n436 DMOD
D437 n436 n437 DMOD
D438 n437 n438 DMOD
D439 n438 n439 DMOD
D440 n439 n440 DMOD
D441 n440 n441 DMOD
D442 n441 n442 DMOD
D443 n442 n443 DMOD
D444 n443 n444 DMOD
D445 n444 n445 DMOD
D446 n445 n446 DMOD
D447 n446 n447 DMOD
D448 n447 n448 DMOD
D449 n448 n449 DMOD
D450 n449 n450 DMOD
D451 n450 n451 DMOD
D452 n451 n452 DMOD
D453 n452 n453 DMOD
D454 n453 n454 DMOD
D455 n454 n455 DMOD
D456 n455 n456 DMOD
D457 n456 n457 DMOD
D458 n457 n458 DMOD
D459 n458 n459 DMOD
D460 n459 n460 DMOD
D461 n460 n461 DMOD
D462 n461 n462 DMOD
D463 n462 n463 DMOD
D464 n463 n464 DMOD
D465 n464 n465 DMOD
D466 n465 n466 DMOD
D467 n466 n467 DMOD
D468 n467 n468 DMOD
D469 n468 n469 DMOD
D470 n469 n470 DMOD
D471 n470 n471 DMOD
D472 n471 n472 DMOD
D473 n472 n473 DMOD
D474 n473 n474 DMOD
D475 n474 n475 DMOD
D476 n475 n476 DMOD
D477 n476 n477 DMOD
D478 n477 n478 DMOD
D479 n478 n479 DMOD
D480 n479 n480 DMOD
D481 n480 n481 DMOD
D482 n481 n482 DMOD
D483 n482 n483 DMOD
D484 n483 n484 DMOD
D485 n484 n485 DMOD
D486 n485 n486 DMOD
D487 n486 n487 DMOD
D488 n487 n488 DMOD
D489 n488 n489 DMOD
D490 n489 n490 DMOD
D491 n490 n491 DMOD
D492 n491 n492 DMOD
D493 n492 n493 DMOD
D494 n493 n494 DMOD
D495 n494 n495 DMOD
D496 n495 n496 DMOD
D497 n496 n497 DMOD
D498 n497 n498 DMOD
D499 n498 n499 DMOD
D500 n499 out DMOD

RLOAD out 0 1k

.OP
.DC V1 0 10 0.1
.END
