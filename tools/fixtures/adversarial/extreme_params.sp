* Extreme parameter values
V1 1 0 DC 1e30
R1 1 2 1e-30
R2 2 0 1e30
.OP
.END
