* MOSFET with missing model
V1 1 0 DC 3.3
M1 2 1 0 0 NONEXISTENT W=10u L=1u
R1 1 2 1k
.OP
.END
