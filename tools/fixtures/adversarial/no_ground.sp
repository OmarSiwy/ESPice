* No ground node — should error
R1 1 2 1k
V1 1 2 DC 5
.OP
.END
