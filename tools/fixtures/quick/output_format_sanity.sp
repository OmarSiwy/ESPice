* Q09: Output Format Sanity — Tiny voltage divider for .OP format testing
V1 in 0 DC 5
R1 in out 1k
R2 out 0 1k
.OP
.END
