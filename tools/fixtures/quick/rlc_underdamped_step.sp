* Q02: RLC Underdamped Step Response — R=10, L=1m, C=100n, resonant ringing
V1 in 0 PULSE(0 1 0 1n 1n 100u 200u)
R1 in mid 10
L1 mid out 1m
C1 out 0 100n
.TRAN 1u 500u
.END
