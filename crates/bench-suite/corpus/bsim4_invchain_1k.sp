* Resistor inverter chain, N=1000 stages
Vdd vdd 0 1.0
Vin in 0 PULSE(0 1 0 1n 1n 20n 40n)
R1a vdd n1 10k
R1b n1 0 10k
C1 n1 0 10f
R2a vdd n2 10k
R2b n2 0 10k
C2 n2 0 10f
R3a vdd n3 10k
R3b n3 0 10k
C3 n3 0 10f
R4a vdd n4 10k
R4b n4 0 10k
C4 n4 0 10f
R5a vdd n5 10k
R5b n5 0 10k
C5 n5 0 10f
R6a vdd n6 10k
R6b n6 0 10k
C6 n6 0 10f
R7a vdd n7 10k
R7b n7 0 10k
C7 n7 0 10f
R8a vdd n8 10k
R8b n8 0 10k
C8 n8 0 10f
R9a vdd n9 10k
R9b n9 0 10k
C9 n9 0 10f
R10a vdd n10 10k
R10b n10 0 10k
C10 n10 0 10f
R11a vdd n11 10k
R11b n11 0 10k
C11 n11 0 10f
R12a vdd n12 10k
R12b n12 0 10k
C12 n12 0 10f
R13a vdd n13 10k
R13b n13 0 10k
C13 n13 0 10f
R14a vdd n14 10k
R14b n14 0 10k
C14 n14 0 10f
R15a vdd n15 10k
R15b n15 0 10k
C15 n15 0 10f
R16a vdd n16 10k
R16b n16 0 10k
C16 n16 0 10f
R17a vdd n17 10k
R17b n17 0 10k
C17 n17 0 10f
R18a vdd n18 10k
R18b n18 0 10k
C18 n18 0 10f
R19a vdd n19 10k
R19b n19 0 10k
C19 n19 0 10f
R20a vdd n20 10k
R20b n20 0 10k
C20 n20 0 10f
R21a vdd n21 10k
R21b n21 0 10k
C21 n21 0 10f
R22a vdd n22 10k
R22b n22 0 10k
C22 n22 0 10f
R23a vdd n23 10k
R23b n23 0 10k
C23 n23 0 10f
R24a vdd n24 10k
R24b n24 0 10k
C24 n24 0 10f
R25a vdd n25 10k
R25b n25 0 10k
C25 n25 0 10f
R26a vdd n26 10k
R26b n26 0 10k
C26 n26 0 10f
R27a vdd n27 10k
R27b n27 0 10k
C27 n27 0 10f
R28a vdd n28 10k
R28b n28 0 10k
C28 n28 0 10f
R29a vdd n29 10k
R29b n29 0 10k
C29 n29 0 10f
R30a vdd n30 10k
R30b n30 0 10k
C30 n30 0 10f
R31a vdd n31 10k
R31b n31 0 10k
C31 n31 0 10f
R32a vdd n32 10k
R32b n32 0 10k
C32 n32 0 10f
R33a vdd n33 10k
R33b n33 0 10k
C33 n33 0 10f
R34a vdd n34 10k
R34b n34 0 10k
C34 n34 0 10f
R35a vdd n35 10k
R35b n35 0 10k
C35 n35 0 10f
R36a vdd n36 10k
R36b n36 0 10k
C36 n36 0 10f
R37a vdd n37 10k
R37b n37 0 10k
C37 n37 0 10f
R38a vdd n38 10k
R38b n38 0 10k
C38 n38 0 10f
R39a vdd n39 10k
R39b n39 0 10k
C39 n39 0 10f
R40a vdd n40 10k
R40b n40 0 10k
C40 n40 0 10f
R41a vdd n41 10k
R41b n41 0 10k
C41 n41 0 10f
R42a vdd n42 10k
R42b n42 0 10k
C42 n42 0 10f
R43a vdd n43 10k
R43b n43 0 10k
C43 n43 0 10f
R44a vdd n44 10k
R44b n44 0 10k
C44 n44 0 10f
R45a vdd n45 10k
R45b n45 0 10k
C45 n45 0 10f
R46a vdd n46 10k
R46b n46 0 10k
C46 n46 0 10f
R47a vdd n47 10k
R47b n47 0 10k
C47 n47 0 10f
R48a vdd n48 10k
R48b n48 0 10k
C48 n48 0 10f
R49a vdd n49 10k
R49b n49 0 10k
C49 n49 0 10f
R50a vdd n50 10k
R50b n50 0 10k
C50 n50 0 10f
R51a vdd n51 10k
R51b n51 0 10k
C51 n51 0 10f
R52a vdd n52 10k
R52b n52 0 10k
C52 n52 0 10f
R53a vdd n53 10k
R53b n53 0 10k
C53 n53 0 10f
R54a vdd n54 10k
R54b n54 0 10k
C54 n54 0 10f
R55a vdd n55 10k
R55b n55 0 10k
C55 n55 0 10f
R56a vdd n56 10k
R56b n56 0 10k
C56 n56 0 10f
R57a vdd n57 10k
R57b n57 0 10k
C57 n57 0 10f
R58a vdd n58 10k
R58b n58 0 10k
C58 n58 0 10f
R59a vdd n59 10k
R59b n59 0 10k
C59 n59 0 10f
R60a vdd n60 10k
R60b n60 0 10k
C60 n60 0 10f
R61a vdd n61 10k
R61b n61 0 10k
C61 n61 0 10f
R62a vdd n62 10k
R62b n62 0 10k
C62 n62 0 10f
R63a vdd n63 10k
R63b n63 0 10k
C63 n63 0 10f
R64a vdd n64 10k
R64b n64 0 10k
C64 n64 0 10f
R65a vdd n65 10k
R65b n65 0 10k
C65 n65 0 10f
R66a vdd n66 10k
R66b n66 0 10k
C66 n66 0 10f
R67a vdd n67 10k
R67b n67 0 10k
C67 n67 0 10f
R68a vdd n68 10k
R68b n68 0 10k
C68 n68 0 10f
R69a vdd n69 10k
R69b n69 0 10k
C69 n69 0 10f
R70a vdd n70 10k
R70b n70 0 10k
C70 n70 0 10f
R71a vdd n71 10k
R71b n71 0 10k
C71 n71 0 10f
R72a vdd n72 10k
R72b n72 0 10k
C72 n72 0 10f
R73a vdd n73 10k
R73b n73 0 10k
C73 n73 0 10f
R74a vdd n74 10k
R74b n74 0 10k
C74 n74 0 10f
R75a vdd n75 10k
R75b n75 0 10k
C75 n75 0 10f
R76a vdd n76 10k
R76b n76 0 10k
C76 n76 0 10f
R77a vdd n77 10k
R77b n77 0 10k
C77 n77 0 10f
R78a vdd n78 10k
R78b n78 0 10k
C78 n78 0 10f
R79a vdd n79 10k
R79b n79 0 10k
C79 n79 0 10f
R80a vdd n80 10k
R80b n80 0 10k
C80 n80 0 10f
R81a vdd n81 10k
R81b n81 0 10k
C81 n81 0 10f
R82a vdd n82 10k
R82b n82 0 10k
C82 n82 0 10f
R83a vdd n83 10k
R83b n83 0 10k
C83 n83 0 10f
R84a vdd n84 10k
R84b n84 0 10k
C84 n84 0 10f
R85a vdd n85 10k
R85b n85 0 10k
C85 n85 0 10f
R86a vdd n86 10k
R86b n86 0 10k
C86 n86 0 10f
R87a vdd n87 10k
R87b n87 0 10k
C87 n87 0 10f
R88a vdd n88 10k
R88b n88 0 10k
C88 n88 0 10f
R89a vdd n89 10k
R89b n89 0 10k
C89 n89 0 10f
R90a vdd n90 10k
R90b n90 0 10k
C90 n90 0 10f
R91a vdd n91 10k
R91b n91 0 10k
C91 n91 0 10f
R92a vdd n92 10k
R92b n92 0 10k
C92 n92 0 10f
R93a vdd n93 10k
R93b n93 0 10k
C93 n93 0 10f
R94a vdd n94 10k
R94b n94 0 10k
C94 n94 0 10f
R95a vdd n95 10k
R95b n95 0 10k
C95 n95 0 10f
R96a vdd n96 10k
R96b n96 0 10k
C96 n96 0 10f
R97a vdd n97 10k
R97b n97 0 10k
C97 n97 0 10f
R98a vdd n98 10k
R98b n98 0 10k
C98 n98 0 10f
R99a vdd n99 10k
R99b n99 0 10k
C99 n99 0 10f
R100a vdd n100 10k
R100b n100 0 10k
C100 n100 0 10f
R101a vdd n101 10k
R101b n101 0 10k
C101 n101 0 10f
R102a vdd n102 10k
R102b n102 0 10k
C102 n102 0 10f
R103a vdd n103 10k
R103b n103 0 10k
C103 n103 0 10f
R104a vdd n104 10k
R104b n104 0 10k
C104 n104 0 10f
R105a vdd n105 10k
R105b n105 0 10k
C105 n105 0 10f
R106a vdd n106 10k
R106b n106 0 10k
C106 n106 0 10f
R107a vdd n107 10k
R107b n107 0 10k
C107 n107 0 10f
R108a vdd n108 10k
R108b n108 0 10k
C108 n108 0 10f
R109a vdd n109 10k
R109b n109 0 10k
C109 n109 0 10f
R110a vdd n110 10k
R110b n110 0 10k
C110 n110 0 10f
R111a vdd n111 10k
R111b n111 0 10k
C111 n111 0 10f
R112a vdd n112 10k
R112b n112 0 10k
C112 n112 0 10f
R113a vdd n113 10k
R113b n113 0 10k
C113 n113 0 10f
R114a vdd n114 10k
R114b n114 0 10k
C114 n114 0 10f
R115a vdd n115 10k
R115b n115 0 10k
C115 n115 0 10f
R116a vdd n116 10k
R116b n116 0 10k
C116 n116 0 10f
R117a vdd n117 10k
R117b n117 0 10k
C117 n117 0 10f
R118a vdd n118 10k
R118b n118 0 10k
C118 n118 0 10f
R119a vdd n119 10k
R119b n119 0 10k
C119 n119 0 10f
R120a vdd n120 10k
R120b n120 0 10k
C120 n120 0 10f
R121a vdd n121 10k
R121b n121 0 10k
C121 n121 0 10f
R122a vdd n122 10k
R122b n122 0 10k
C122 n122 0 10f
R123a vdd n123 10k
R123b n123 0 10k
C123 n123 0 10f
R124a vdd n124 10k
R124b n124 0 10k
C124 n124 0 10f
R125a vdd n125 10k
R125b n125 0 10k
C125 n125 0 10f
R126a vdd n126 10k
R126b n126 0 10k
C126 n126 0 10f
R127a vdd n127 10k
R127b n127 0 10k
C127 n127 0 10f
R128a vdd n128 10k
R128b n128 0 10k
C128 n128 0 10f
R129a vdd n129 10k
R129b n129 0 10k
C129 n129 0 10f
R130a vdd n130 10k
R130b n130 0 10k
C130 n130 0 10f
R131a vdd n131 10k
R131b n131 0 10k
C131 n131 0 10f
R132a vdd n132 10k
R132b n132 0 10k
C132 n132 0 10f
R133a vdd n133 10k
R133b n133 0 10k
C133 n133 0 10f
R134a vdd n134 10k
R134b n134 0 10k
C134 n134 0 10f
R135a vdd n135 10k
R135b n135 0 10k
C135 n135 0 10f
R136a vdd n136 10k
R136b n136 0 10k
C136 n136 0 10f
R137a vdd n137 10k
R137b n137 0 10k
C137 n137 0 10f
R138a vdd n138 10k
R138b n138 0 10k
C138 n138 0 10f
R139a vdd n139 10k
R139b n139 0 10k
C139 n139 0 10f
R140a vdd n140 10k
R140b n140 0 10k
C140 n140 0 10f
R141a vdd n141 10k
R141b n141 0 10k
C141 n141 0 10f
R142a vdd n142 10k
R142b n142 0 10k
C142 n142 0 10f
R143a vdd n143 10k
R143b n143 0 10k
C143 n143 0 10f
R144a vdd n144 10k
R144b n144 0 10k
C144 n144 0 10f
R145a vdd n145 10k
R145b n145 0 10k
C145 n145 0 10f
R146a vdd n146 10k
R146b n146 0 10k
C146 n146 0 10f
R147a vdd n147 10k
R147b n147 0 10k
C147 n147 0 10f
R148a vdd n148 10k
R148b n148 0 10k
C148 n148 0 10f
R149a vdd n149 10k
R149b n149 0 10k
C149 n149 0 10f
R150a vdd n150 10k
R150b n150 0 10k
C150 n150 0 10f
R151a vdd n151 10k
R151b n151 0 10k
C151 n151 0 10f
R152a vdd n152 10k
R152b n152 0 10k
C152 n152 0 10f
R153a vdd n153 10k
R153b n153 0 10k
C153 n153 0 10f
R154a vdd n154 10k
R154b n154 0 10k
C154 n154 0 10f
R155a vdd n155 10k
R155b n155 0 10k
C155 n155 0 10f
R156a vdd n156 10k
R156b n156 0 10k
C156 n156 0 10f
R157a vdd n157 10k
R157b n157 0 10k
C157 n157 0 10f
R158a vdd n158 10k
R158b n158 0 10k
C158 n158 0 10f
R159a vdd n159 10k
R159b n159 0 10k
C159 n159 0 10f
R160a vdd n160 10k
R160b n160 0 10k
C160 n160 0 10f
R161a vdd n161 10k
R161b n161 0 10k
C161 n161 0 10f
R162a vdd n162 10k
R162b n162 0 10k
C162 n162 0 10f
R163a vdd n163 10k
R163b n163 0 10k
C163 n163 0 10f
R164a vdd n164 10k
R164b n164 0 10k
C164 n164 0 10f
R165a vdd n165 10k
R165b n165 0 10k
C165 n165 0 10f
R166a vdd n166 10k
R166b n166 0 10k
C166 n166 0 10f
R167a vdd n167 10k
R167b n167 0 10k
C167 n167 0 10f
R168a vdd n168 10k
R168b n168 0 10k
C168 n168 0 10f
R169a vdd n169 10k
R169b n169 0 10k
C169 n169 0 10f
R170a vdd n170 10k
R170b n170 0 10k
C170 n170 0 10f
R171a vdd n171 10k
R171b n171 0 10k
C171 n171 0 10f
R172a vdd n172 10k
R172b n172 0 10k
C172 n172 0 10f
R173a vdd n173 10k
R173b n173 0 10k
C173 n173 0 10f
R174a vdd n174 10k
R174b n174 0 10k
C174 n174 0 10f
R175a vdd n175 10k
R175b n175 0 10k
C175 n175 0 10f
R176a vdd n176 10k
R176b n176 0 10k
C176 n176 0 10f
R177a vdd n177 10k
R177b n177 0 10k
C177 n177 0 10f
R178a vdd n178 10k
R178b n178 0 10k
C178 n178 0 10f
R179a vdd n179 10k
R179b n179 0 10k
C179 n179 0 10f
R180a vdd n180 10k
R180b n180 0 10k
C180 n180 0 10f
R181a vdd n181 10k
R181b n181 0 10k
C181 n181 0 10f
R182a vdd n182 10k
R182b n182 0 10k
C182 n182 0 10f
R183a vdd n183 10k
R183b n183 0 10k
C183 n183 0 10f
R184a vdd n184 10k
R184b n184 0 10k
C184 n184 0 10f
R185a vdd n185 10k
R185b n185 0 10k
C185 n185 0 10f
R186a vdd n186 10k
R186b n186 0 10k
C186 n186 0 10f
R187a vdd n187 10k
R187b n187 0 10k
C187 n187 0 10f
R188a vdd n188 10k
R188b n188 0 10k
C188 n188 0 10f
R189a vdd n189 10k
R189b n189 0 10k
C189 n189 0 10f
R190a vdd n190 10k
R190b n190 0 10k
C190 n190 0 10f
R191a vdd n191 10k
R191b n191 0 10k
C191 n191 0 10f
R192a vdd n192 10k
R192b n192 0 10k
C192 n192 0 10f
R193a vdd n193 10k
R193b n193 0 10k
C193 n193 0 10f
R194a vdd n194 10k
R194b n194 0 10k
C194 n194 0 10f
R195a vdd n195 10k
R195b n195 0 10k
C195 n195 0 10f
R196a vdd n196 10k
R196b n196 0 10k
C196 n196 0 10f
R197a vdd n197 10k
R197b n197 0 10k
C197 n197 0 10f
R198a vdd n198 10k
R198b n198 0 10k
C198 n198 0 10f
R199a vdd n199 10k
R199b n199 0 10k
C199 n199 0 10f
R200a vdd n200 10k
R200b n200 0 10k
C200 n200 0 10f
R201a vdd n201 10k
R201b n201 0 10k
C201 n201 0 10f
R202a vdd n202 10k
R202b n202 0 10k
C202 n202 0 10f
R203a vdd n203 10k
R203b n203 0 10k
C203 n203 0 10f
R204a vdd n204 10k
R204b n204 0 10k
C204 n204 0 10f
R205a vdd n205 10k
R205b n205 0 10k
C205 n205 0 10f
R206a vdd n206 10k
R206b n206 0 10k
C206 n206 0 10f
R207a vdd n207 10k
R207b n207 0 10k
C207 n207 0 10f
R208a vdd n208 10k
R208b n208 0 10k
C208 n208 0 10f
R209a vdd n209 10k
R209b n209 0 10k
C209 n209 0 10f
R210a vdd n210 10k
R210b n210 0 10k
C210 n210 0 10f
R211a vdd n211 10k
R211b n211 0 10k
C211 n211 0 10f
R212a vdd n212 10k
R212b n212 0 10k
C212 n212 0 10f
R213a vdd n213 10k
R213b n213 0 10k
C213 n213 0 10f
R214a vdd n214 10k
R214b n214 0 10k
C214 n214 0 10f
R215a vdd n215 10k
R215b n215 0 10k
C215 n215 0 10f
R216a vdd n216 10k
R216b n216 0 10k
C216 n216 0 10f
R217a vdd n217 10k
R217b n217 0 10k
C217 n217 0 10f
R218a vdd n218 10k
R218b n218 0 10k
C218 n218 0 10f
R219a vdd n219 10k
R219b n219 0 10k
C219 n219 0 10f
R220a vdd n220 10k
R220b n220 0 10k
C220 n220 0 10f
R221a vdd n221 10k
R221b n221 0 10k
C221 n221 0 10f
R222a vdd n222 10k
R222b n222 0 10k
C222 n222 0 10f
R223a vdd n223 10k
R223b n223 0 10k
C223 n223 0 10f
R224a vdd n224 10k
R224b n224 0 10k
C224 n224 0 10f
R225a vdd n225 10k
R225b n225 0 10k
C225 n225 0 10f
R226a vdd n226 10k
R226b n226 0 10k
C226 n226 0 10f
R227a vdd n227 10k
R227b n227 0 10k
C227 n227 0 10f
R228a vdd n228 10k
R228b n228 0 10k
C228 n228 0 10f
R229a vdd n229 10k
R229b n229 0 10k
C229 n229 0 10f
R230a vdd n230 10k
R230b n230 0 10k
C230 n230 0 10f
R231a vdd n231 10k
R231b n231 0 10k
C231 n231 0 10f
R232a vdd n232 10k
R232b n232 0 10k
C232 n232 0 10f
R233a vdd n233 10k
R233b n233 0 10k
C233 n233 0 10f
R234a vdd n234 10k
R234b n234 0 10k
C234 n234 0 10f
R235a vdd n235 10k
R235b n235 0 10k
C235 n235 0 10f
R236a vdd n236 10k
R236b n236 0 10k
C236 n236 0 10f
R237a vdd n237 10k
R237b n237 0 10k
C237 n237 0 10f
R238a vdd n238 10k
R238b n238 0 10k
C238 n238 0 10f
R239a vdd n239 10k
R239b n239 0 10k
C239 n239 0 10f
R240a vdd n240 10k
R240b n240 0 10k
C240 n240 0 10f
R241a vdd n241 10k
R241b n241 0 10k
C241 n241 0 10f
R242a vdd n242 10k
R242b n242 0 10k
C242 n242 0 10f
R243a vdd n243 10k
R243b n243 0 10k
C243 n243 0 10f
R244a vdd n244 10k
R244b n244 0 10k
C244 n244 0 10f
R245a vdd n245 10k
R245b n245 0 10k
C245 n245 0 10f
R246a vdd n246 10k
R246b n246 0 10k
C246 n246 0 10f
R247a vdd n247 10k
R247b n247 0 10k
C247 n247 0 10f
R248a vdd n248 10k
R248b n248 0 10k
C248 n248 0 10f
R249a vdd n249 10k
R249b n249 0 10k
C249 n249 0 10f
R250a vdd n250 10k
R250b n250 0 10k
C250 n250 0 10f
R251a vdd n251 10k
R251b n251 0 10k
C251 n251 0 10f
R252a vdd n252 10k
R252b n252 0 10k
C252 n252 0 10f
R253a vdd n253 10k
R253b n253 0 10k
C253 n253 0 10f
R254a vdd n254 10k
R254b n254 0 10k
C254 n254 0 10f
R255a vdd n255 10k
R255b n255 0 10k
C255 n255 0 10f
R256a vdd n256 10k
R256b n256 0 10k
C256 n256 0 10f
R257a vdd n257 10k
R257b n257 0 10k
C257 n257 0 10f
R258a vdd n258 10k
R258b n258 0 10k
C258 n258 0 10f
R259a vdd n259 10k
R259b n259 0 10k
C259 n259 0 10f
R260a vdd n260 10k
R260b n260 0 10k
C260 n260 0 10f
R261a vdd n261 10k
R261b n261 0 10k
C261 n261 0 10f
R262a vdd n262 10k
R262b n262 0 10k
C262 n262 0 10f
R263a vdd n263 10k
R263b n263 0 10k
C263 n263 0 10f
R264a vdd n264 10k
R264b n264 0 10k
C264 n264 0 10f
R265a vdd n265 10k
R265b n265 0 10k
C265 n265 0 10f
R266a vdd n266 10k
R266b n266 0 10k
C266 n266 0 10f
R267a vdd n267 10k
R267b n267 0 10k
C267 n267 0 10f
R268a vdd n268 10k
R268b n268 0 10k
C268 n268 0 10f
R269a vdd n269 10k
R269b n269 0 10k
C269 n269 0 10f
R270a vdd n270 10k
R270b n270 0 10k
C270 n270 0 10f
R271a vdd n271 10k
R271b n271 0 10k
C271 n271 0 10f
R272a vdd n272 10k
R272b n272 0 10k
C272 n272 0 10f
R273a vdd n273 10k
R273b n273 0 10k
C273 n273 0 10f
R274a vdd n274 10k
R274b n274 0 10k
C274 n274 0 10f
R275a vdd n275 10k
R275b n275 0 10k
C275 n275 0 10f
R276a vdd n276 10k
R276b n276 0 10k
C276 n276 0 10f
R277a vdd n277 10k
R277b n277 0 10k
C277 n277 0 10f
R278a vdd n278 10k
R278b n278 0 10k
C278 n278 0 10f
R279a vdd n279 10k
R279b n279 0 10k
C279 n279 0 10f
R280a vdd n280 10k
R280b n280 0 10k
C280 n280 0 10f
R281a vdd n281 10k
R281b n281 0 10k
C281 n281 0 10f
R282a vdd n282 10k
R282b n282 0 10k
C282 n282 0 10f
R283a vdd n283 10k
R283b n283 0 10k
C283 n283 0 10f
R284a vdd n284 10k
R284b n284 0 10k
C284 n284 0 10f
R285a vdd n285 10k
R285b n285 0 10k
C285 n285 0 10f
R286a vdd n286 10k
R286b n286 0 10k
C286 n286 0 10f
R287a vdd n287 10k
R287b n287 0 10k
C287 n287 0 10f
R288a vdd n288 10k
R288b n288 0 10k
C288 n288 0 10f
R289a vdd n289 10k
R289b n289 0 10k
C289 n289 0 10f
R290a vdd n290 10k
R290b n290 0 10k
C290 n290 0 10f
R291a vdd n291 10k
R291b n291 0 10k
C291 n291 0 10f
R292a vdd n292 10k
R292b n292 0 10k
C292 n292 0 10f
R293a vdd n293 10k
R293b n293 0 10k
C293 n293 0 10f
R294a vdd n294 10k
R294b n294 0 10k
C294 n294 0 10f
R295a vdd n295 10k
R295b n295 0 10k
C295 n295 0 10f
R296a vdd n296 10k
R296b n296 0 10k
C296 n296 0 10f
R297a vdd n297 10k
R297b n297 0 10k
C297 n297 0 10f
R298a vdd n298 10k
R298b n298 0 10k
C298 n298 0 10f
R299a vdd n299 10k
R299b n299 0 10k
C299 n299 0 10f
R300a vdd n300 10k
R300b n300 0 10k
C300 n300 0 10f
R301a vdd n301 10k
R301b n301 0 10k
C301 n301 0 10f
R302a vdd n302 10k
R302b n302 0 10k
C302 n302 0 10f
R303a vdd n303 10k
R303b n303 0 10k
C303 n303 0 10f
R304a vdd n304 10k
R304b n304 0 10k
C304 n304 0 10f
R305a vdd n305 10k
R305b n305 0 10k
C305 n305 0 10f
R306a vdd n306 10k
R306b n306 0 10k
C306 n306 0 10f
R307a vdd n307 10k
R307b n307 0 10k
C307 n307 0 10f
R308a vdd n308 10k
R308b n308 0 10k
C308 n308 0 10f
R309a vdd n309 10k
R309b n309 0 10k
C309 n309 0 10f
R310a vdd n310 10k
R310b n310 0 10k
C310 n310 0 10f
R311a vdd n311 10k
R311b n311 0 10k
C311 n311 0 10f
R312a vdd n312 10k
R312b n312 0 10k
C312 n312 0 10f
R313a vdd n313 10k
R313b n313 0 10k
C313 n313 0 10f
R314a vdd n314 10k
R314b n314 0 10k
C314 n314 0 10f
R315a vdd n315 10k
R315b n315 0 10k
C315 n315 0 10f
R316a vdd n316 10k
R316b n316 0 10k
C316 n316 0 10f
R317a vdd n317 10k
R317b n317 0 10k
C317 n317 0 10f
R318a vdd n318 10k
R318b n318 0 10k
C318 n318 0 10f
R319a vdd n319 10k
R319b n319 0 10k
C319 n319 0 10f
R320a vdd n320 10k
R320b n320 0 10k
C320 n320 0 10f
R321a vdd n321 10k
R321b n321 0 10k
C321 n321 0 10f
R322a vdd n322 10k
R322b n322 0 10k
C322 n322 0 10f
R323a vdd n323 10k
R323b n323 0 10k
C323 n323 0 10f
R324a vdd n324 10k
R324b n324 0 10k
C324 n324 0 10f
R325a vdd n325 10k
R325b n325 0 10k
C325 n325 0 10f
R326a vdd n326 10k
R326b n326 0 10k
C326 n326 0 10f
R327a vdd n327 10k
R327b n327 0 10k
C327 n327 0 10f
R328a vdd n328 10k
R328b n328 0 10k
C328 n328 0 10f
R329a vdd n329 10k
R329b n329 0 10k
C329 n329 0 10f
R330a vdd n330 10k
R330b n330 0 10k
C330 n330 0 10f
R331a vdd n331 10k
R331b n331 0 10k
C331 n331 0 10f
R332a vdd n332 10k
R332b n332 0 10k
C332 n332 0 10f
R333a vdd n333 10k
R333b n333 0 10k
C333 n333 0 10f
R334a vdd n334 10k
R334b n334 0 10k
C334 n334 0 10f
R335a vdd n335 10k
R335b n335 0 10k
C335 n335 0 10f
R336a vdd n336 10k
R336b n336 0 10k
C336 n336 0 10f
R337a vdd n337 10k
R337b n337 0 10k
C337 n337 0 10f
R338a vdd n338 10k
R338b n338 0 10k
C338 n338 0 10f
R339a vdd n339 10k
R339b n339 0 10k
C339 n339 0 10f
R340a vdd n340 10k
R340b n340 0 10k
C340 n340 0 10f
R341a vdd n341 10k
R341b n341 0 10k
C341 n341 0 10f
R342a vdd n342 10k
R342b n342 0 10k
C342 n342 0 10f
R343a vdd n343 10k
R343b n343 0 10k
C343 n343 0 10f
R344a vdd n344 10k
R344b n344 0 10k
C344 n344 0 10f
R345a vdd n345 10k
R345b n345 0 10k
C345 n345 0 10f
R346a vdd n346 10k
R346b n346 0 10k
C346 n346 0 10f
R347a vdd n347 10k
R347b n347 0 10k
C347 n347 0 10f
R348a vdd n348 10k
R348b n348 0 10k
C348 n348 0 10f
R349a vdd n349 10k
R349b n349 0 10k
C349 n349 0 10f
R350a vdd n350 10k
R350b n350 0 10k
C350 n350 0 10f
R351a vdd n351 10k
R351b n351 0 10k
C351 n351 0 10f
R352a vdd n352 10k
R352b n352 0 10k
C352 n352 0 10f
R353a vdd n353 10k
R353b n353 0 10k
C353 n353 0 10f
R354a vdd n354 10k
R354b n354 0 10k
C354 n354 0 10f
R355a vdd n355 10k
R355b n355 0 10k
C355 n355 0 10f
R356a vdd n356 10k
R356b n356 0 10k
C356 n356 0 10f
R357a vdd n357 10k
R357b n357 0 10k
C357 n357 0 10f
R358a vdd n358 10k
R358b n358 0 10k
C358 n358 0 10f
R359a vdd n359 10k
R359b n359 0 10k
C359 n359 0 10f
R360a vdd n360 10k
R360b n360 0 10k
C360 n360 0 10f
R361a vdd n361 10k
R361b n361 0 10k
C361 n361 0 10f
R362a vdd n362 10k
R362b n362 0 10k
C362 n362 0 10f
R363a vdd n363 10k
R363b n363 0 10k
C363 n363 0 10f
R364a vdd n364 10k
R364b n364 0 10k
C364 n364 0 10f
R365a vdd n365 10k
R365b n365 0 10k
C365 n365 0 10f
R366a vdd n366 10k
R366b n366 0 10k
C366 n366 0 10f
R367a vdd n367 10k
R367b n367 0 10k
C367 n367 0 10f
R368a vdd n368 10k
R368b n368 0 10k
C368 n368 0 10f
R369a vdd n369 10k
R369b n369 0 10k
C369 n369 0 10f
R370a vdd n370 10k
R370b n370 0 10k
C370 n370 0 10f
R371a vdd n371 10k
R371b n371 0 10k
C371 n371 0 10f
R372a vdd n372 10k
R372b n372 0 10k
C372 n372 0 10f
R373a vdd n373 10k
R373b n373 0 10k
C373 n373 0 10f
R374a vdd n374 10k
R374b n374 0 10k
C374 n374 0 10f
R375a vdd n375 10k
R375b n375 0 10k
C375 n375 0 10f
R376a vdd n376 10k
R376b n376 0 10k
C376 n376 0 10f
R377a vdd n377 10k
R377b n377 0 10k
C377 n377 0 10f
R378a vdd n378 10k
R378b n378 0 10k
C378 n378 0 10f
R379a vdd n379 10k
R379b n379 0 10k
C379 n379 0 10f
R380a vdd n380 10k
R380b n380 0 10k
C380 n380 0 10f
R381a vdd n381 10k
R381b n381 0 10k
C381 n381 0 10f
R382a vdd n382 10k
R382b n382 0 10k
C382 n382 0 10f
R383a vdd n383 10k
R383b n383 0 10k
C383 n383 0 10f
R384a vdd n384 10k
R384b n384 0 10k
C384 n384 0 10f
R385a vdd n385 10k
R385b n385 0 10k
C385 n385 0 10f
R386a vdd n386 10k
R386b n386 0 10k
C386 n386 0 10f
R387a vdd n387 10k
R387b n387 0 10k
C387 n387 0 10f
R388a vdd n388 10k
R388b n388 0 10k
C388 n388 0 10f
R389a vdd n389 10k
R389b n389 0 10k
C389 n389 0 10f
R390a vdd n390 10k
R390b n390 0 10k
C390 n390 0 10f
R391a vdd n391 10k
R391b n391 0 10k
C391 n391 0 10f
R392a vdd n392 10k
R392b n392 0 10k
C392 n392 0 10f
R393a vdd n393 10k
R393b n393 0 10k
C393 n393 0 10f
R394a vdd n394 10k
R394b n394 0 10k
C394 n394 0 10f
R395a vdd n395 10k
R395b n395 0 10k
C395 n395 0 10f
R396a vdd n396 10k
R396b n396 0 10k
C396 n396 0 10f
R397a vdd n397 10k
R397b n397 0 10k
C397 n397 0 10f
R398a vdd n398 10k
R398b n398 0 10k
C398 n398 0 10f
R399a vdd n399 10k
R399b n399 0 10k
C399 n399 0 10f
R400a vdd n400 10k
R400b n400 0 10k
C400 n400 0 10f
R401a vdd n401 10k
R401b n401 0 10k
C401 n401 0 10f
R402a vdd n402 10k
R402b n402 0 10k
C402 n402 0 10f
R403a vdd n403 10k
R403b n403 0 10k
C403 n403 0 10f
R404a vdd n404 10k
R404b n404 0 10k
C404 n404 0 10f
R405a vdd n405 10k
R405b n405 0 10k
C405 n405 0 10f
R406a vdd n406 10k
R406b n406 0 10k
C406 n406 0 10f
R407a vdd n407 10k
R407b n407 0 10k
C407 n407 0 10f
R408a vdd n408 10k
R408b n408 0 10k
C408 n408 0 10f
R409a vdd n409 10k
R409b n409 0 10k
C409 n409 0 10f
R410a vdd n410 10k
R410b n410 0 10k
C410 n410 0 10f
R411a vdd n411 10k
R411b n411 0 10k
C411 n411 0 10f
R412a vdd n412 10k
R412b n412 0 10k
C412 n412 0 10f
R413a vdd n413 10k
R413b n413 0 10k
C413 n413 0 10f
R414a vdd n414 10k
R414b n414 0 10k
C414 n414 0 10f
R415a vdd n415 10k
R415b n415 0 10k
C415 n415 0 10f
R416a vdd n416 10k
R416b n416 0 10k
C416 n416 0 10f
R417a vdd n417 10k
R417b n417 0 10k
C417 n417 0 10f
R418a vdd n418 10k
R418b n418 0 10k
C418 n418 0 10f
R419a vdd n419 10k
R419b n419 0 10k
C419 n419 0 10f
R420a vdd n420 10k
R420b n420 0 10k
C420 n420 0 10f
R421a vdd n421 10k
R421b n421 0 10k
C421 n421 0 10f
R422a vdd n422 10k
R422b n422 0 10k
C422 n422 0 10f
R423a vdd n423 10k
R423b n423 0 10k
C423 n423 0 10f
R424a vdd n424 10k
R424b n424 0 10k
C424 n424 0 10f
R425a vdd n425 10k
R425b n425 0 10k
C425 n425 0 10f
R426a vdd n426 10k
R426b n426 0 10k
C426 n426 0 10f
R427a vdd n427 10k
R427b n427 0 10k
C427 n427 0 10f
R428a vdd n428 10k
R428b n428 0 10k
C428 n428 0 10f
R429a vdd n429 10k
R429b n429 0 10k
C429 n429 0 10f
R430a vdd n430 10k
R430b n430 0 10k
C430 n430 0 10f
R431a vdd n431 10k
R431b n431 0 10k
C431 n431 0 10f
R432a vdd n432 10k
R432b n432 0 10k
C432 n432 0 10f
R433a vdd n433 10k
R433b n433 0 10k
C433 n433 0 10f
R434a vdd n434 10k
R434b n434 0 10k
C434 n434 0 10f
R435a vdd n435 10k
R435b n435 0 10k
C435 n435 0 10f
R436a vdd n436 10k
R436b n436 0 10k
C436 n436 0 10f
R437a vdd n437 10k
R437b n437 0 10k
C437 n437 0 10f
R438a vdd n438 10k
R438b n438 0 10k
C438 n438 0 10f
R439a vdd n439 10k
R439b n439 0 10k
C439 n439 0 10f
R440a vdd n440 10k
R440b n440 0 10k
C440 n440 0 10f
R441a vdd n441 10k
R441b n441 0 10k
C441 n441 0 10f
R442a vdd n442 10k
R442b n442 0 10k
C442 n442 0 10f
R443a vdd n443 10k
R443b n443 0 10k
C443 n443 0 10f
R444a vdd n444 10k
R444b n444 0 10k
C444 n444 0 10f
R445a vdd n445 10k
R445b n445 0 10k
C445 n445 0 10f
R446a vdd n446 10k
R446b n446 0 10k
C446 n446 0 10f
R447a vdd n447 10k
R447b n447 0 10k
C447 n447 0 10f
R448a vdd n448 10k
R448b n448 0 10k
C448 n448 0 10f
R449a vdd n449 10k
R449b n449 0 10k
C449 n449 0 10f
R450a vdd n450 10k
R450b n450 0 10k
C450 n450 0 10f
R451a vdd n451 10k
R451b n451 0 10k
C451 n451 0 10f
R452a vdd n452 10k
R452b n452 0 10k
C452 n452 0 10f
R453a vdd n453 10k
R453b n453 0 10k
C453 n453 0 10f
R454a vdd n454 10k
R454b n454 0 10k
C454 n454 0 10f
R455a vdd n455 10k
R455b n455 0 10k
C455 n455 0 10f
R456a vdd n456 10k
R456b n456 0 10k
C456 n456 0 10f
R457a vdd n457 10k
R457b n457 0 10k
C457 n457 0 10f
R458a vdd n458 10k
R458b n458 0 10k
C458 n458 0 10f
R459a vdd n459 10k
R459b n459 0 10k
C459 n459 0 10f
R460a vdd n460 10k
R460b n460 0 10k
C460 n460 0 10f
R461a vdd n461 10k
R461b n461 0 10k
C461 n461 0 10f
R462a vdd n462 10k
R462b n462 0 10k
C462 n462 0 10f
R463a vdd n463 10k
R463b n463 0 10k
C463 n463 0 10f
R464a vdd n464 10k
R464b n464 0 10k
C464 n464 0 10f
R465a vdd n465 10k
R465b n465 0 10k
C465 n465 0 10f
R466a vdd n466 10k
R466b n466 0 10k
C466 n466 0 10f
R467a vdd n467 10k
R467b n467 0 10k
C467 n467 0 10f
R468a vdd n468 10k
R468b n468 0 10k
C468 n468 0 10f
R469a vdd n469 10k
R469b n469 0 10k
C469 n469 0 10f
R470a vdd n470 10k
R470b n470 0 10k
C470 n470 0 10f
R471a vdd n471 10k
R471b n471 0 10k
C471 n471 0 10f
R472a vdd n472 10k
R472b n472 0 10k
C472 n472 0 10f
R473a vdd n473 10k
R473b n473 0 10k
C473 n473 0 10f
R474a vdd n474 10k
R474b n474 0 10k
C474 n474 0 10f
R475a vdd n475 10k
R475b n475 0 10k
C475 n475 0 10f
R476a vdd n476 10k
R476b n476 0 10k
C476 n476 0 10f
R477a vdd n477 10k
R477b n477 0 10k
C477 n477 0 10f
R478a vdd n478 10k
R478b n478 0 10k
C478 n478 0 10f
R479a vdd n479 10k
R479b n479 0 10k
C479 n479 0 10f
R480a vdd n480 10k
R480b n480 0 10k
C480 n480 0 10f
R481a vdd n481 10k
R481b n481 0 10k
C481 n481 0 10f
R482a vdd n482 10k
R482b n482 0 10k
C482 n482 0 10f
R483a vdd n483 10k
R483b n483 0 10k
C483 n483 0 10f
R484a vdd n484 10k
R484b n484 0 10k
C484 n484 0 10f
R485a vdd n485 10k
R485b n485 0 10k
C485 n485 0 10f
R486a vdd n486 10k
R486b n486 0 10k
C486 n486 0 10f
R487a vdd n487 10k
R487b n487 0 10k
C487 n487 0 10f
R488a vdd n488 10k
R488b n488 0 10k
C488 n488 0 10f
R489a vdd n489 10k
R489b n489 0 10k
C489 n489 0 10f
R490a vdd n490 10k
R490b n490 0 10k
C490 n490 0 10f
R491a vdd n491 10k
R491b n491 0 10k
C491 n491 0 10f
R492a vdd n492 10k
R492b n492 0 10k
C492 n492 0 10f
R493a vdd n493 10k
R493b n493 0 10k
C493 n493 0 10f
R494a vdd n494 10k
R494b n494 0 10k
C494 n494 0 10f
R495a vdd n495 10k
R495b n495 0 10k
C495 n495 0 10f
R496a vdd n496 10k
R496b n496 0 10k
C496 n496 0 10f
R497a vdd n497 10k
R497b n497 0 10k
C497 n497 0 10f
R498a vdd n498 10k
R498b n498 0 10k
C498 n498 0 10f
R499a vdd n499 10k
R499b n499 0 10k
C499 n499 0 10f
R500a vdd n500 10k
R500b n500 0 10k
C500 n500 0 10f
R501a vdd n501 10k
R501b n501 0 10k
C501 n501 0 10f
R502a vdd n502 10k
R502b n502 0 10k
C502 n502 0 10f
R503a vdd n503 10k
R503b n503 0 10k
C503 n503 0 10f
R504a vdd n504 10k
R504b n504 0 10k
C504 n504 0 10f
R505a vdd n505 10k
R505b n505 0 10k
C505 n505 0 10f
R506a vdd n506 10k
R506b n506 0 10k
C506 n506 0 10f
R507a vdd n507 10k
R507b n507 0 10k
C507 n507 0 10f
R508a vdd n508 10k
R508b n508 0 10k
C508 n508 0 10f
R509a vdd n509 10k
R509b n509 0 10k
C509 n509 0 10f
R510a vdd n510 10k
R510b n510 0 10k
C510 n510 0 10f
R511a vdd n511 10k
R511b n511 0 10k
C511 n511 0 10f
R512a vdd n512 10k
R512b n512 0 10k
C512 n512 0 10f
R513a vdd n513 10k
R513b n513 0 10k
C513 n513 0 10f
R514a vdd n514 10k
R514b n514 0 10k
C514 n514 0 10f
R515a vdd n515 10k
R515b n515 0 10k
C515 n515 0 10f
R516a vdd n516 10k
R516b n516 0 10k
C516 n516 0 10f
R517a vdd n517 10k
R517b n517 0 10k
C517 n517 0 10f
R518a vdd n518 10k
R518b n518 0 10k
C518 n518 0 10f
R519a vdd n519 10k
R519b n519 0 10k
C519 n519 0 10f
R520a vdd n520 10k
R520b n520 0 10k
C520 n520 0 10f
R521a vdd n521 10k
R521b n521 0 10k
C521 n521 0 10f
R522a vdd n522 10k
R522b n522 0 10k
C522 n522 0 10f
R523a vdd n523 10k
R523b n523 0 10k
C523 n523 0 10f
R524a vdd n524 10k
R524b n524 0 10k
C524 n524 0 10f
R525a vdd n525 10k
R525b n525 0 10k
C525 n525 0 10f
R526a vdd n526 10k
R526b n526 0 10k
C526 n526 0 10f
R527a vdd n527 10k
R527b n527 0 10k
C527 n527 0 10f
R528a vdd n528 10k
R528b n528 0 10k
C528 n528 0 10f
R529a vdd n529 10k
R529b n529 0 10k
C529 n529 0 10f
R530a vdd n530 10k
R530b n530 0 10k
C530 n530 0 10f
R531a vdd n531 10k
R531b n531 0 10k
C531 n531 0 10f
R532a vdd n532 10k
R532b n532 0 10k
C532 n532 0 10f
R533a vdd n533 10k
R533b n533 0 10k
C533 n533 0 10f
R534a vdd n534 10k
R534b n534 0 10k
C534 n534 0 10f
R535a vdd n535 10k
R535b n535 0 10k
C535 n535 0 10f
R536a vdd n536 10k
R536b n536 0 10k
C536 n536 0 10f
R537a vdd n537 10k
R537b n537 0 10k
C537 n537 0 10f
R538a vdd n538 10k
R538b n538 0 10k
C538 n538 0 10f
R539a vdd n539 10k
R539b n539 0 10k
C539 n539 0 10f
R540a vdd n540 10k
R540b n540 0 10k
C540 n540 0 10f
R541a vdd n541 10k
R541b n541 0 10k
C541 n541 0 10f
R542a vdd n542 10k
R542b n542 0 10k
C542 n542 0 10f
R543a vdd n543 10k
R543b n543 0 10k
C543 n543 0 10f
R544a vdd n544 10k
R544b n544 0 10k
C544 n544 0 10f
R545a vdd n545 10k
R545b n545 0 10k
C545 n545 0 10f
R546a vdd n546 10k
R546b n546 0 10k
C546 n546 0 10f
R547a vdd n547 10k
R547b n547 0 10k
C547 n547 0 10f
R548a vdd n548 10k
R548b n548 0 10k
C548 n548 0 10f
R549a vdd n549 10k
R549b n549 0 10k
C549 n549 0 10f
R550a vdd n550 10k
R550b n550 0 10k
C550 n550 0 10f
R551a vdd n551 10k
R551b n551 0 10k
C551 n551 0 10f
R552a vdd n552 10k
R552b n552 0 10k
C552 n552 0 10f
R553a vdd n553 10k
R553b n553 0 10k
C553 n553 0 10f
R554a vdd n554 10k
R554b n554 0 10k
C554 n554 0 10f
R555a vdd n555 10k
R555b n555 0 10k
C555 n555 0 10f
R556a vdd n556 10k
R556b n556 0 10k
C556 n556 0 10f
R557a vdd n557 10k
R557b n557 0 10k
C557 n557 0 10f
R558a vdd n558 10k
R558b n558 0 10k
C558 n558 0 10f
R559a vdd n559 10k
R559b n559 0 10k
C559 n559 0 10f
R560a vdd n560 10k
R560b n560 0 10k
C560 n560 0 10f
R561a vdd n561 10k
R561b n561 0 10k
C561 n561 0 10f
R562a vdd n562 10k
R562b n562 0 10k
C562 n562 0 10f
R563a vdd n563 10k
R563b n563 0 10k
C563 n563 0 10f
R564a vdd n564 10k
R564b n564 0 10k
C564 n564 0 10f
R565a vdd n565 10k
R565b n565 0 10k
C565 n565 0 10f
R566a vdd n566 10k
R566b n566 0 10k
C566 n566 0 10f
R567a vdd n567 10k
R567b n567 0 10k
C567 n567 0 10f
R568a vdd n568 10k
R568b n568 0 10k
C568 n568 0 10f
R569a vdd n569 10k
R569b n569 0 10k
C569 n569 0 10f
R570a vdd n570 10k
R570b n570 0 10k
C570 n570 0 10f
R571a vdd n571 10k
R571b n571 0 10k
C571 n571 0 10f
R572a vdd n572 10k
R572b n572 0 10k
C572 n572 0 10f
R573a vdd n573 10k
R573b n573 0 10k
C573 n573 0 10f
R574a vdd n574 10k
R574b n574 0 10k
C574 n574 0 10f
R575a vdd n575 10k
R575b n575 0 10k
C575 n575 0 10f
R576a vdd n576 10k
R576b n576 0 10k
C576 n576 0 10f
R577a vdd n577 10k
R577b n577 0 10k
C577 n577 0 10f
R578a vdd n578 10k
R578b n578 0 10k
C578 n578 0 10f
R579a vdd n579 10k
R579b n579 0 10k
C579 n579 0 10f
R580a vdd n580 10k
R580b n580 0 10k
C580 n580 0 10f
R581a vdd n581 10k
R581b n581 0 10k
C581 n581 0 10f
R582a vdd n582 10k
R582b n582 0 10k
C582 n582 0 10f
R583a vdd n583 10k
R583b n583 0 10k
C583 n583 0 10f
R584a vdd n584 10k
R584b n584 0 10k
C584 n584 0 10f
R585a vdd n585 10k
R585b n585 0 10k
C585 n585 0 10f
R586a vdd n586 10k
R586b n586 0 10k
C586 n586 0 10f
R587a vdd n587 10k
R587b n587 0 10k
C587 n587 0 10f
R588a vdd n588 10k
R588b n588 0 10k
C588 n588 0 10f
R589a vdd n589 10k
R589b n589 0 10k
C589 n589 0 10f
R590a vdd n590 10k
R590b n590 0 10k
C590 n590 0 10f
R591a vdd n591 10k
R591b n591 0 10k
C591 n591 0 10f
R592a vdd n592 10k
R592b n592 0 10k
C592 n592 0 10f
R593a vdd n593 10k
R593b n593 0 10k
C593 n593 0 10f
R594a vdd n594 10k
R594b n594 0 10k
C594 n594 0 10f
R595a vdd n595 10k
R595b n595 0 10k
C595 n595 0 10f
R596a vdd n596 10k
R596b n596 0 10k
C596 n596 0 10f
R597a vdd n597 10k
R597b n597 0 10k
C597 n597 0 10f
R598a vdd n598 10k
R598b n598 0 10k
C598 n598 0 10f
R599a vdd n599 10k
R599b n599 0 10k
C599 n599 0 10f
R600a vdd n600 10k
R600b n600 0 10k
C600 n600 0 10f
R601a vdd n601 10k
R601b n601 0 10k
C601 n601 0 10f
R602a vdd n602 10k
R602b n602 0 10k
C602 n602 0 10f
R603a vdd n603 10k
R603b n603 0 10k
C603 n603 0 10f
R604a vdd n604 10k
R604b n604 0 10k
C604 n604 0 10f
R605a vdd n605 10k
R605b n605 0 10k
C605 n605 0 10f
R606a vdd n606 10k
R606b n606 0 10k
C606 n606 0 10f
R607a vdd n607 10k
R607b n607 0 10k
C607 n607 0 10f
R608a vdd n608 10k
R608b n608 0 10k
C608 n608 0 10f
R609a vdd n609 10k
R609b n609 0 10k
C609 n609 0 10f
R610a vdd n610 10k
R610b n610 0 10k
C610 n610 0 10f
R611a vdd n611 10k
R611b n611 0 10k
C611 n611 0 10f
R612a vdd n612 10k
R612b n612 0 10k
C612 n612 0 10f
R613a vdd n613 10k
R613b n613 0 10k
C613 n613 0 10f
R614a vdd n614 10k
R614b n614 0 10k
C614 n614 0 10f
R615a vdd n615 10k
R615b n615 0 10k
C615 n615 0 10f
R616a vdd n616 10k
R616b n616 0 10k
C616 n616 0 10f
R617a vdd n617 10k
R617b n617 0 10k
C617 n617 0 10f
R618a vdd n618 10k
R618b n618 0 10k
C618 n618 0 10f
R619a vdd n619 10k
R619b n619 0 10k
C619 n619 0 10f
R620a vdd n620 10k
R620b n620 0 10k
C620 n620 0 10f
R621a vdd n621 10k
R621b n621 0 10k
C621 n621 0 10f
R622a vdd n622 10k
R622b n622 0 10k
C622 n622 0 10f
R623a vdd n623 10k
R623b n623 0 10k
C623 n623 0 10f
R624a vdd n624 10k
R624b n624 0 10k
C624 n624 0 10f
R625a vdd n625 10k
R625b n625 0 10k
C625 n625 0 10f
R626a vdd n626 10k
R626b n626 0 10k
C626 n626 0 10f
R627a vdd n627 10k
R627b n627 0 10k
C627 n627 0 10f
R628a vdd n628 10k
R628b n628 0 10k
C628 n628 0 10f
R629a vdd n629 10k
R629b n629 0 10k
C629 n629 0 10f
R630a vdd n630 10k
R630b n630 0 10k
C630 n630 0 10f
R631a vdd n631 10k
R631b n631 0 10k
C631 n631 0 10f
R632a vdd n632 10k
R632b n632 0 10k
C632 n632 0 10f
R633a vdd n633 10k
R633b n633 0 10k
C633 n633 0 10f
R634a vdd n634 10k
R634b n634 0 10k
C634 n634 0 10f
R635a vdd n635 10k
R635b n635 0 10k
C635 n635 0 10f
R636a vdd n636 10k
R636b n636 0 10k
C636 n636 0 10f
R637a vdd n637 10k
R637b n637 0 10k
C637 n637 0 10f
R638a vdd n638 10k
R638b n638 0 10k
C638 n638 0 10f
R639a vdd n639 10k
R639b n639 0 10k
C639 n639 0 10f
R640a vdd n640 10k
R640b n640 0 10k
C640 n640 0 10f
R641a vdd n641 10k
R641b n641 0 10k
C641 n641 0 10f
R642a vdd n642 10k
R642b n642 0 10k
C642 n642 0 10f
R643a vdd n643 10k
R643b n643 0 10k
C643 n643 0 10f
R644a vdd n644 10k
R644b n644 0 10k
C644 n644 0 10f
R645a vdd n645 10k
R645b n645 0 10k
C645 n645 0 10f
R646a vdd n646 10k
R646b n646 0 10k
C646 n646 0 10f
R647a vdd n647 10k
R647b n647 0 10k
C647 n647 0 10f
R648a vdd n648 10k
R648b n648 0 10k
C648 n648 0 10f
R649a vdd n649 10k
R649b n649 0 10k
C649 n649 0 10f
R650a vdd n650 10k
R650b n650 0 10k
C650 n650 0 10f
R651a vdd n651 10k
R651b n651 0 10k
C651 n651 0 10f
R652a vdd n652 10k
R652b n652 0 10k
C652 n652 0 10f
R653a vdd n653 10k
R653b n653 0 10k
C653 n653 0 10f
R654a vdd n654 10k
R654b n654 0 10k
C654 n654 0 10f
R655a vdd n655 10k
R655b n655 0 10k
C655 n655 0 10f
R656a vdd n656 10k
R656b n656 0 10k
C656 n656 0 10f
R657a vdd n657 10k
R657b n657 0 10k
C657 n657 0 10f
R658a vdd n658 10k
R658b n658 0 10k
C658 n658 0 10f
R659a vdd n659 10k
R659b n659 0 10k
C659 n659 0 10f
R660a vdd n660 10k
R660b n660 0 10k
C660 n660 0 10f
R661a vdd n661 10k
R661b n661 0 10k
C661 n661 0 10f
R662a vdd n662 10k
R662b n662 0 10k
C662 n662 0 10f
R663a vdd n663 10k
R663b n663 0 10k
C663 n663 0 10f
R664a vdd n664 10k
R664b n664 0 10k
C664 n664 0 10f
R665a vdd n665 10k
R665b n665 0 10k
C665 n665 0 10f
R666a vdd n666 10k
R666b n666 0 10k
C666 n666 0 10f
R667a vdd n667 10k
R667b n667 0 10k
C667 n667 0 10f
R668a vdd n668 10k
R668b n668 0 10k
C668 n668 0 10f
R669a vdd n669 10k
R669b n669 0 10k
C669 n669 0 10f
R670a vdd n670 10k
R670b n670 0 10k
C670 n670 0 10f
R671a vdd n671 10k
R671b n671 0 10k
C671 n671 0 10f
R672a vdd n672 10k
R672b n672 0 10k
C672 n672 0 10f
R673a vdd n673 10k
R673b n673 0 10k
C673 n673 0 10f
R674a vdd n674 10k
R674b n674 0 10k
C674 n674 0 10f
R675a vdd n675 10k
R675b n675 0 10k
C675 n675 0 10f
R676a vdd n676 10k
R676b n676 0 10k
C676 n676 0 10f
R677a vdd n677 10k
R677b n677 0 10k
C677 n677 0 10f
R678a vdd n678 10k
R678b n678 0 10k
C678 n678 0 10f
R679a vdd n679 10k
R679b n679 0 10k
C679 n679 0 10f
R680a vdd n680 10k
R680b n680 0 10k
C680 n680 0 10f
R681a vdd n681 10k
R681b n681 0 10k
C681 n681 0 10f
R682a vdd n682 10k
R682b n682 0 10k
C682 n682 0 10f
R683a vdd n683 10k
R683b n683 0 10k
C683 n683 0 10f
R684a vdd n684 10k
R684b n684 0 10k
C684 n684 0 10f
R685a vdd n685 10k
R685b n685 0 10k
C685 n685 0 10f
R686a vdd n686 10k
R686b n686 0 10k
C686 n686 0 10f
R687a vdd n687 10k
R687b n687 0 10k
C687 n687 0 10f
R688a vdd n688 10k
R688b n688 0 10k
C688 n688 0 10f
R689a vdd n689 10k
R689b n689 0 10k
C689 n689 0 10f
R690a vdd n690 10k
R690b n690 0 10k
C690 n690 0 10f
R691a vdd n691 10k
R691b n691 0 10k
C691 n691 0 10f
R692a vdd n692 10k
R692b n692 0 10k
C692 n692 0 10f
R693a vdd n693 10k
R693b n693 0 10k
C693 n693 0 10f
R694a vdd n694 10k
R694b n694 0 10k
C694 n694 0 10f
R695a vdd n695 10k
R695b n695 0 10k
C695 n695 0 10f
R696a vdd n696 10k
R696b n696 0 10k
C696 n696 0 10f
R697a vdd n697 10k
R697b n697 0 10k
C697 n697 0 10f
R698a vdd n698 10k
R698b n698 0 10k
C698 n698 0 10f
R699a vdd n699 10k
R699b n699 0 10k
C699 n699 0 10f
R700a vdd n700 10k
R700b n700 0 10k
C700 n700 0 10f
R701a vdd n701 10k
R701b n701 0 10k
C701 n701 0 10f
R702a vdd n702 10k
R702b n702 0 10k
C702 n702 0 10f
R703a vdd n703 10k
R703b n703 0 10k
C703 n703 0 10f
R704a vdd n704 10k
R704b n704 0 10k
C704 n704 0 10f
R705a vdd n705 10k
R705b n705 0 10k
C705 n705 0 10f
R706a vdd n706 10k
R706b n706 0 10k
C706 n706 0 10f
R707a vdd n707 10k
R707b n707 0 10k
C707 n707 0 10f
R708a vdd n708 10k
R708b n708 0 10k
C708 n708 0 10f
R709a vdd n709 10k
R709b n709 0 10k
C709 n709 0 10f
R710a vdd n710 10k
R710b n710 0 10k
C710 n710 0 10f
R711a vdd n711 10k
R711b n711 0 10k
C711 n711 0 10f
R712a vdd n712 10k
R712b n712 0 10k
C712 n712 0 10f
R713a vdd n713 10k
R713b n713 0 10k
C713 n713 0 10f
R714a vdd n714 10k
R714b n714 0 10k
C714 n714 0 10f
R715a vdd n715 10k
R715b n715 0 10k
C715 n715 0 10f
R716a vdd n716 10k
R716b n716 0 10k
C716 n716 0 10f
R717a vdd n717 10k
R717b n717 0 10k
C717 n717 0 10f
R718a vdd n718 10k
R718b n718 0 10k
C718 n718 0 10f
R719a vdd n719 10k
R719b n719 0 10k
C719 n719 0 10f
R720a vdd n720 10k
R720b n720 0 10k
C720 n720 0 10f
R721a vdd n721 10k
R721b n721 0 10k
C721 n721 0 10f
R722a vdd n722 10k
R722b n722 0 10k
C722 n722 0 10f
R723a vdd n723 10k
R723b n723 0 10k
C723 n723 0 10f
R724a vdd n724 10k
R724b n724 0 10k
C724 n724 0 10f
R725a vdd n725 10k
R725b n725 0 10k
C725 n725 0 10f
R726a vdd n726 10k
R726b n726 0 10k
C726 n726 0 10f
R727a vdd n727 10k
R727b n727 0 10k
C727 n727 0 10f
R728a vdd n728 10k
R728b n728 0 10k
C728 n728 0 10f
R729a vdd n729 10k
R729b n729 0 10k
C729 n729 0 10f
R730a vdd n730 10k
R730b n730 0 10k
C730 n730 0 10f
R731a vdd n731 10k
R731b n731 0 10k
C731 n731 0 10f
R732a vdd n732 10k
R732b n732 0 10k
C732 n732 0 10f
R733a vdd n733 10k
R733b n733 0 10k
C733 n733 0 10f
R734a vdd n734 10k
R734b n734 0 10k
C734 n734 0 10f
R735a vdd n735 10k
R735b n735 0 10k
C735 n735 0 10f
R736a vdd n736 10k
R736b n736 0 10k
C736 n736 0 10f
R737a vdd n737 10k
R737b n737 0 10k
C737 n737 0 10f
R738a vdd n738 10k
R738b n738 0 10k
C738 n738 0 10f
R739a vdd n739 10k
R739b n739 0 10k
C739 n739 0 10f
R740a vdd n740 10k
R740b n740 0 10k
C740 n740 0 10f
R741a vdd n741 10k
R741b n741 0 10k
C741 n741 0 10f
R742a vdd n742 10k
R742b n742 0 10k
C742 n742 0 10f
R743a vdd n743 10k
R743b n743 0 10k
C743 n743 0 10f
R744a vdd n744 10k
R744b n744 0 10k
C744 n744 0 10f
R745a vdd n745 10k
R745b n745 0 10k
C745 n745 0 10f
R746a vdd n746 10k
R746b n746 0 10k
C746 n746 0 10f
R747a vdd n747 10k
R747b n747 0 10k
C747 n747 0 10f
R748a vdd n748 10k
R748b n748 0 10k
C748 n748 0 10f
R749a vdd n749 10k
R749b n749 0 10k
C749 n749 0 10f
R750a vdd n750 10k
R750b n750 0 10k
C750 n750 0 10f
R751a vdd n751 10k
R751b n751 0 10k
C751 n751 0 10f
R752a vdd n752 10k
R752b n752 0 10k
C752 n752 0 10f
R753a vdd n753 10k
R753b n753 0 10k
C753 n753 0 10f
R754a vdd n754 10k
R754b n754 0 10k
C754 n754 0 10f
R755a vdd n755 10k
R755b n755 0 10k
C755 n755 0 10f
R756a vdd n756 10k
R756b n756 0 10k
C756 n756 0 10f
R757a vdd n757 10k
R757b n757 0 10k
C757 n757 0 10f
R758a vdd n758 10k
R758b n758 0 10k
C758 n758 0 10f
R759a vdd n759 10k
R759b n759 0 10k
C759 n759 0 10f
R760a vdd n760 10k
R760b n760 0 10k
C760 n760 0 10f
R761a vdd n761 10k
R761b n761 0 10k
C761 n761 0 10f
R762a vdd n762 10k
R762b n762 0 10k
C762 n762 0 10f
R763a vdd n763 10k
R763b n763 0 10k
C763 n763 0 10f
R764a vdd n764 10k
R764b n764 0 10k
C764 n764 0 10f
R765a vdd n765 10k
R765b n765 0 10k
C765 n765 0 10f
R766a vdd n766 10k
R766b n766 0 10k
C766 n766 0 10f
R767a vdd n767 10k
R767b n767 0 10k
C767 n767 0 10f
R768a vdd n768 10k
R768b n768 0 10k
C768 n768 0 10f
R769a vdd n769 10k
R769b n769 0 10k
C769 n769 0 10f
R770a vdd n770 10k
R770b n770 0 10k
C770 n770 0 10f
R771a vdd n771 10k
R771b n771 0 10k
C771 n771 0 10f
R772a vdd n772 10k
R772b n772 0 10k
C772 n772 0 10f
R773a vdd n773 10k
R773b n773 0 10k
C773 n773 0 10f
R774a vdd n774 10k
R774b n774 0 10k
C774 n774 0 10f
R775a vdd n775 10k
R775b n775 0 10k
C775 n775 0 10f
R776a vdd n776 10k
R776b n776 0 10k
C776 n776 0 10f
R777a vdd n777 10k
R777b n777 0 10k
C777 n777 0 10f
R778a vdd n778 10k
R778b n778 0 10k
C778 n778 0 10f
R779a vdd n779 10k
R779b n779 0 10k
C779 n779 0 10f
R780a vdd n780 10k
R780b n780 0 10k
C780 n780 0 10f
R781a vdd n781 10k
R781b n781 0 10k
C781 n781 0 10f
R782a vdd n782 10k
R782b n782 0 10k
C782 n782 0 10f
R783a vdd n783 10k
R783b n783 0 10k
C783 n783 0 10f
R784a vdd n784 10k
R784b n784 0 10k
C784 n784 0 10f
R785a vdd n785 10k
R785b n785 0 10k
C785 n785 0 10f
R786a vdd n786 10k
R786b n786 0 10k
C786 n786 0 10f
R787a vdd n787 10k
R787b n787 0 10k
C787 n787 0 10f
R788a vdd n788 10k
R788b n788 0 10k
C788 n788 0 10f
R789a vdd n789 10k
R789b n789 0 10k
C789 n789 0 10f
R790a vdd n790 10k
R790b n790 0 10k
C790 n790 0 10f
R791a vdd n791 10k
R791b n791 0 10k
C791 n791 0 10f
R792a vdd n792 10k
R792b n792 0 10k
C792 n792 0 10f
R793a vdd n793 10k
R793b n793 0 10k
C793 n793 0 10f
R794a vdd n794 10k
R794b n794 0 10k
C794 n794 0 10f
R795a vdd n795 10k
R795b n795 0 10k
C795 n795 0 10f
R796a vdd n796 10k
R796b n796 0 10k
C796 n796 0 10f
R797a vdd n797 10k
R797b n797 0 10k
C797 n797 0 10f
R798a vdd n798 10k
R798b n798 0 10k
C798 n798 0 10f
R799a vdd n799 10k
R799b n799 0 10k
C799 n799 0 10f
R800a vdd n800 10k
R800b n800 0 10k
C800 n800 0 10f
R801a vdd n801 10k
R801b n801 0 10k
C801 n801 0 10f
R802a vdd n802 10k
R802b n802 0 10k
C802 n802 0 10f
R803a vdd n803 10k
R803b n803 0 10k
C803 n803 0 10f
R804a vdd n804 10k
R804b n804 0 10k
C804 n804 0 10f
R805a vdd n805 10k
R805b n805 0 10k
C805 n805 0 10f
R806a vdd n806 10k
R806b n806 0 10k
C806 n806 0 10f
R807a vdd n807 10k
R807b n807 0 10k
C807 n807 0 10f
R808a vdd n808 10k
R808b n808 0 10k
C808 n808 0 10f
R809a vdd n809 10k
R809b n809 0 10k
C809 n809 0 10f
R810a vdd n810 10k
R810b n810 0 10k
C810 n810 0 10f
R811a vdd n811 10k
R811b n811 0 10k
C811 n811 0 10f
R812a vdd n812 10k
R812b n812 0 10k
C812 n812 0 10f
R813a vdd n813 10k
R813b n813 0 10k
C813 n813 0 10f
R814a vdd n814 10k
R814b n814 0 10k
C814 n814 0 10f
R815a vdd n815 10k
R815b n815 0 10k
C815 n815 0 10f
R816a vdd n816 10k
R816b n816 0 10k
C816 n816 0 10f
R817a vdd n817 10k
R817b n817 0 10k
C817 n817 0 10f
R818a vdd n818 10k
R818b n818 0 10k
C818 n818 0 10f
R819a vdd n819 10k
R819b n819 0 10k
C819 n819 0 10f
R820a vdd n820 10k
R820b n820 0 10k
C820 n820 0 10f
R821a vdd n821 10k
R821b n821 0 10k
C821 n821 0 10f
R822a vdd n822 10k
R822b n822 0 10k
C822 n822 0 10f
R823a vdd n823 10k
R823b n823 0 10k
C823 n823 0 10f
R824a vdd n824 10k
R824b n824 0 10k
C824 n824 0 10f
R825a vdd n825 10k
R825b n825 0 10k
C825 n825 0 10f
R826a vdd n826 10k
R826b n826 0 10k
C826 n826 0 10f
R827a vdd n827 10k
R827b n827 0 10k
C827 n827 0 10f
R828a vdd n828 10k
R828b n828 0 10k
C828 n828 0 10f
R829a vdd n829 10k
R829b n829 0 10k
C829 n829 0 10f
R830a vdd n830 10k
R830b n830 0 10k
C830 n830 0 10f
R831a vdd n831 10k
R831b n831 0 10k
C831 n831 0 10f
R832a vdd n832 10k
R832b n832 0 10k
C832 n832 0 10f
R833a vdd n833 10k
R833b n833 0 10k
C833 n833 0 10f
R834a vdd n834 10k
R834b n834 0 10k
C834 n834 0 10f
R835a vdd n835 10k
R835b n835 0 10k
C835 n835 0 10f
R836a vdd n836 10k
R836b n836 0 10k
C836 n836 0 10f
R837a vdd n837 10k
R837b n837 0 10k
C837 n837 0 10f
R838a vdd n838 10k
R838b n838 0 10k
C838 n838 0 10f
R839a vdd n839 10k
R839b n839 0 10k
C839 n839 0 10f
R840a vdd n840 10k
R840b n840 0 10k
C840 n840 0 10f
R841a vdd n841 10k
R841b n841 0 10k
C841 n841 0 10f
R842a vdd n842 10k
R842b n842 0 10k
C842 n842 0 10f
R843a vdd n843 10k
R843b n843 0 10k
C843 n843 0 10f
R844a vdd n844 10k
R844b n844 0 10k
C844 n844 0 10f
R845a vdd n845 10k
R845b n845 0 10k
C845 n845 0 10f
R846a vdd n846 10k
R846b n846 0 10k
C846 n846 0 10f
R847a vdd n847 10k
R847b n847 0 10k
C847 n847 0 10f
R848a vdd n848 10k
R848b n848 0 10k
C848 n848 0 10f
R849a vdd n849 10k
R849b n849 0 10k
C849 n849 0 10f
R850a vdd n850 10k
R850b n850 0 10k
C850 n850 0 10f
R851a vdd n851 10k
R851b n851 0 10k
C851 n851 0 10f
R852a vdd n852 10k
R852b n852 0 10k
C852 n852 0 10f
R853a vdd n853 10k
R853b n853 0 10k
C853 n853 0 10f
R854a vdd n854 10k
R854b n854 0 10k
C854 n854 0 10f
R855a vdd n855 10k
R855b n855 0 10k
C855 n855 0 10f
R856a vdd n856 10k
R856b n856 0 10k
C856 n856 0 10f
R857a vdd n857 10k
R857b n857 0 10k
C857 n857 0 10f
R858a vdd n858 10k
R858b n858 0 10k
C858 n858 0 10f
R859a vdd n859 10k
R859b n859 0 10k
C859 n859 0 10f
R860a vdd n860 10k
R860b n860 0 10k
C860 n860 0 10f
R861a vdd n861 10k
R861b n861 0 10k
C861 n861 0 10f
R862a vdd n862 10k
R862b n862 0 10k
C862 n862 0 10f
R863a vdd n863 10k
R863b n863 0 10k
C863 n863 0 10f
R864a vdd n864 10k
R864b n864 0 10k
C864 n864 0 10f
R865a vdd n865 10k
R865b n865 0 10k
C865 n865 0 10f
R866a vdd n866 10k
R866b n866 0 10k
C866 n866 0 10f
R867a vdd n867 10k
R867b n867 0 10k
C867 n867 0 10f
R868a vdd n868 10k
R868b n868 0 10k
C868 n868 0 10f
R869a vdd n869 10k
R869b n869 0 10k
C869 n869 0 10f
R870a vdd n870 10k
R870b n870 0 10k
C870 n870 0 10f
R871a vdd n871 10k
R871b n871 0 10k
C871 n871 0 10f
R872a vdd n872 10k
R872b n872 0 10k
C872 n872 0 10f
R873a vdd n873 10k
R873b n873 0 10k
C873 n873 0 10f
R874a vdd n874 10k
R874b n874 0 10k
C874 n874 0 10f
R875a vdd n875 10k
R875b n875 0 10k
C875 n875 0 10f
R876a vdd n876 10k
R876b n876 0 10k
C876 n876 0 10f
R877a vdd n877 10k
R877b n877 0 10k
C877 n877 0 10f
R878a vdd n878 10k
R878b n878 0 10k
C878 n878 0 10f
R879a vdd n879 10k
R879b n879 0 10k
C879 n879 0 10f
R880a vdd n880 10k
R880b n880 0 10k
C880 n880 0 10f
R881a vdd n881 10k
R881b n881 0 10k
C881 n881 0 10f
R882a vdd n882 10k
R882b n882 0 10k
C882 n882 0 10f
R883a vdd n883 10k
R883b n883 0 10k
C883 n883 0 10f
R884a vdd n884 10k
R884b n884 0 10k
C884 n884 0 10f
R885a vdd n885 10k
R885b n885 0 10k
C885 n885 0 10f
R886a vdd n886 10k
R886b n886 0 10k
C886 n886 0 10f
R887a vdd n887 10k
R887b n887 0 10k
C887 n887 0 10f
R888a vdd n888 10k
R888b n888 0 10k
C888 n888 0 10f
R889a vdd n889 10k
R889b n889 0 10k
C889 n889 0 10f
R890a vdd n890 10k
R890b n890 0 10k
C890 n890 0 10f
R891a vdd n891 10k
R891b n891 0 10k
C891 n891 0 10f
R892a vdd n892 10k
R892b n892 0 10k
C892 n892 0 10f
R893a vdd n893 10k
R893b n893 0 10k
C893 n893 0 10f
R894a vdd n894 10k
R894b n894 0 10k
C894 n894 0 10f
R895a vdd n895 10k
R895b n895 0 10k
C895 n895 0 10f
R896a vdd n896 10k
R896b n896 0 10k
C896 n896 0 10f
R897a vdd n897 10k
R897b n897 0 10k
C897 n897 0 10f
R898a vdd n898 10k
R898b n898 0 10k
C898 n898 0 10f
R899a vdd n899 10k
R899b n899 0 10k
C899 n899 0 10f
R900a vdd n900 10k
R900b n900 0 10k
C900 n900 0 10f
R901a vdd n901 10k
R901b n901 0 10k
C901 n901 0 10f
R902a vdd n902 10k
R902b n902 0 10k
C902 n902 0 10f
R903a vdd n903 10k
R903b n903 0 10k
C903 n903 0 10f
R904a vdd n904 10k
R904b n904 0 10k
C904 n904 0 10f
R905a vdd n905 10k
R905b n905 0 10k
C905 n905 0 10f
R906a vdd n906 10k
R906b n906 0 10k
C906 n906 0 10f
R907a vdd n907 10k
R907b n907 0 10k
C907 n907 0 10f
R908a vdd n908 10k
R908b n908 0 10k
C908 n908 0 10f
R909a vdd n909 10k
R909b n909 0 10k
C909 n909 0 10f
R910a vdd n910 10k
R910b n910 0 10k
C910 n910 0 10f
R911a vdd n911 10k
R911b n911 0 10k
C911 n911 0 10f
R912a vdd n912 10k
R912b n912 0 10k
C912 n912 0 10f
R913a vdd n913 10k
R913b n913 0 10k
C913 n913 0 10f
R914a vdd n914 10k
R914b n914 0 10k
C914 n914 0 10f
R915a vdd n915 10k
R915b n915 0 10k
C915 n915 0 10f
R916a vdd n916 10k
R916b n916 0 10k
C916 n916 0 10f
R917a vdd n917 10k
R917b n917 0 10k
C917 n917 0 10f
R918a vdd n918 10k
R918b n918 0 10k
C918 n918 0 10f
R919a vdd n919 10k
R919b n919 0 10k
C919 n919 0 10f
R920a vdd n920 10k
R920b n920 0 10k
C920 n920 0 10f
R921a vdd n921 10k
R921b n921 0 10k
C921 n921 0 10f
R922a vdd n922 10k
R922b n922 0 10k
C922 n922 0 10f
R923a vdd n923 10k
R923b n923 0 10k
C923 n923 0 10f
R924a vdd n924 10k
R924b n924 0 10k
C924 n924 0 10f
R925a vdd n925 10k
R925b n925 0 10k
C925 n925 0 10f
R926a vdd n926 10k
R926b n926 0 10k
C926 n926 0 10f
R927a vdd n927 10k
R927b n927 0 10k
C927 n927 0 10f
R928a vdd n928 10k
R928b n928 0 10k
C928 n928 0 10f
R929a vdd n929 10k
R929b n929 0 10k
C929 n929 0 10f
R930a vdd n930 10k
R930b n930 0 10k
C930 n930 0 10f
R931a vdd n931 10k
R931b n931 0 10k
C931 n931 0 10f
R932a vdd n932 10k
R932b n932 0 10k
C932 n932 0 10f
R933a vdd n933 10k
R933b n933 0 10k
C933 n933 0 10f
R934a vdd n934 10k
R934b n934 0 10k
C934 n934 0 10f
R935a vdd n935 10k
R935b n935 0 10k
C935 n935 0 10f
R936a vdd n936 10k
R936b n936 0 10k
C936 n936 0 10f
R937a vdd n937 10k
R937b n937 0 10k
C937 n937 0 10f
R938a vdd n938 10k
R938b n938 0 10k
C938 n938 0 10f
R939a vdd n939 10k
R939b n939 0 10k
C939 n939 0 10f
R940a vdd n940 10k
R940b n940 0 10k
C940 n940 0 10f
R941a vdd n941 10k
R941b n941 0 10k
C941 n941 0 10f
R942a vdd n942 10k
R942b n942 0 10k
C942 n942 0 10f
R943a vdd n943 10k
R943b n943 0 10k
C943 n943 0 10f
R944a vdd n944 10k
R944b n944 0 10k
C944 n944 0 10f
R945a vdd n945 10k
R945b n945 0 10k
C945 n945 0 10f
R946a vdd n946 10k
R946b n946 0 10k
C946 n946 0 10f
R947a vdd n947 10k
R947b n947 0 10k
C947 n947 0 10f
R948a vdd n948 10k
R948b n948 0 10k
C948 n948 0 10f
R949a vdd n949 10k
R949b n949 0 10k
C949 n949 0 10f
R950a vdd n950 10k
R950b n950 0 10k
C950 n950 0 10f
R951a vdd n951 10k
R951b n951 0 10k
C951 n951 0 10f
R952a vdd n952 10k
R952b n952 0 10k
C952 n952 0 10f
R953a vdd n953 10k
R953b n953 0 10k
C953 n953 0 10f
R954a vdd n954 10k
R954b n954 0 10k
C954 n954 0 10f
R955a vdd n955 10k
R955b n955 0 10k
C955 n955 0 10f
R956a vdd n956 10k
R956b n956 0 10k
C956 n956 0 10f
R957a vdd n957 10k
R957b n957 0 10k
C957 n957 0 10f
R958a vdd n958 10k
R958b n958 0 10k
C958 n958 0 10f
R959a vdd n959 10k
R959b n959 0 10k
C959 n959 0 10f
R960a vdd n960 10k
R960b n960 0 10k
C960 n960 0 10f
R961a vdd n961 10k
R961b n961 0 10k
C961 n961 0 10f
R962a vdd n962 10k
R962b n962 0 10k
C962 n962 0 10f
R963a vdd n963 10k
R963b n963 0 10k
C963 n963 0 10f
R964a vdd n964 10k
R964b n964 0 10k
C964 n964 0 10f
R965a vdd n965 10k
R965b n965 0 10k
C965 n965 0 10f
R966a vdd n966 10k
R966b n966 0 10k
C966 n966 0 10f
R967a vdd n967 10k
R967b n967 0 10k
C967 n967 0 10f
R968a vdd n968 10k
R968b n968 0 10k
C968 n968 0 10f
R969a vdd n969 10k
R969b n969 0 10k
C969 n969 0 10f
R970a vdd n970 10k
R970b n970 0 10k
C970 n970 0 10f
R971a vdd n971 10k
R971b n971 0 10k
C971 n971 0 10f
R972a vdd n972 10k
R972b n972 0 10k
C972 n972 0 10f
R973a vdd n973 10k
R973b n973 0 10k
C973 n973 0 10f
R974a vdd n974 10k
R974b n974 0 10k
C974 n974 0 10f
R975a vdd n975 10k
R975b n975 0 10k
C975 n975 0 10f
R976a vdd n976 10k
R976b n976 0 10k
C976 n976 0 10f
R977a vdd n977 10k
R977b n977 0 10k
C977 n977 0 10f
R978a vdd n978 10k
R978b n978 0 10k
C978 n978 0 10f
R979a vdd n979 10k
R979b n979 0 10k
C979 n979 0 10f
R980a vdd n980 10k
R980b n980 0 10k
C980 n980 0 10f
R981a vdd n981 10k
R981b n981 0 10k
C981 n981 0 10f
R982a vdd n982 10k
R982b n982 0 10k
C982 n982 0 10f
R983a vdd n983 10k
R983b n983 0 10k
C983 n983 0 10f
R984a vdd n984 10k
R984b n984 0 10k
C984 n984 0 10f
R985a vdd n985 10k
R985b n985 0 10k
C985 n985 0 10f
R986a vdd n986 10k
R986b n986 0 10k
C986 n986 0 10f
R987a vdd n987 10k
R987b n987 0 10k
C987 n987 0 10f
R988a vdd n988 10k
R988b n988 0 10k
C988 n988 0 10f
R989a vdd n989 10k
R989b n989 0 10k
C989 n989 0 10f
R990a vdd n990 10k
R990b n990 0 10k
C990 n990 0 10f
R991a vdd n991 10k
R991b n991 0 10k
C991 n991 0 10f
R992a vdd n992 10k
R992b n992 0 10k
C992 n992 0 10f
R993a vdd n993 10k
R993b n993 0 10k
C993 n993 0 10f
R994a vdd n994 10k
R994b n994 0 10k
C994 n994 0 10f
R995a vdd n995 10k
R995b n995 0 10k
C995 n995 0 10f
R996a vdd n996 10k
R996b n996 0 10k
C996 n996 0 10f
R997a vdd n997 10k
R997b n997 0 10k
C997 n997 0 10f
R998a vdd n998 10k
R998b n998 0 10k
C998 n998 0 10f
R999a vdd n999 10k
R999b n999 0 10k
C999 n999 0 10f
R1000a vdd n1000 10k
R1000b n1000 0 10k
C1000 n1000 0 10f
.tran 1n 80n
.end
