* Resistor inverter chain, N=100 stages
Vdd vdd 0 1.0
Vin in 0 PULSE(0 1 0 1n 1n 20n 40n)
R1a vdd n1 10k
R1b n1 0 10k
C1 n1 0 10f
R2a vdd n2 10k
R2b n2 0 10k
C2 n2 0 10f
R3a vdd n3 10k
R3b n3 0 10k
C3 n3 0 10f
R4a vdd n4 10k
R4b n4 0 10k
C4 n4 0 10f
R5a vdd n5 10k
R5b n5 0 10k
C5 n5 0 10f
R6a vdd n6 10k
R6b n6 0 10k
C6 n6 0 10f
R7a vdd n7 10k
R7b n7 0 10k
C7 n7 0 10f
R8a vdd n8 10k
R8b n8 0 10k
C8 n8 0 10f
R9a vdd n9 10k
R9b n9 0 10k
C9 n9 0 10f
R10a vdd n10 10k
R10b n10 0 10k
C10 n10 0 10f
R11a vdd n11 10k
R11b n11 0 10k
C11 n11 0 10f
R12a vdd n12 10k
R12b n12 0 10k
C12 n12 0 10f
R13a vdd n13 10k
R13b n13 0 10k
C13 n13 0 10f
R14a vdd n14 10k
R14b n14 0 10k
C14 n14 0 10f
R15a vdd n15 10k
R15b n15 0 10k
C15 n15 0 10f
R16a vdd n16 10k
R16b n16 0 10k
C16 n16 0 10f
R17a vdd n17 10k
R17b n17 0 10k
C17 n17 0 10f
R18a vdd n18 10k
R18b n18 0 10k
C18 n18 0 10f
R19a vdd n19 10k
R19b n19 0 10k
C19 n19 0 10f
R20a vdd n20 10k
R20b n20 0 10k
C20 n20 0 10f
R21a vdd n21 10k
R21b n21 0 10k
C21 n21 0 10f
R22a vdd n22 10k
R22b n22 0 10k
C22 n22 0 10f
R23a vdd n23 10k
R23b n23 0 10k
C23 n23 0 10f
R24a vdd n24 10k
R24b n24 0 10k
C24 n24 0 10f
R25a vdd n25 10k
R25b n25 0 10k
C25 n25 0 10f
R26a vdd n26 10k
R26b n26 0 10k
C26 n26 0 10f
R27a vdd n27 10k
R27b n27 0 10k
C27 n27 0 10f
R28a vdd n28 10k
R28b n28 0 10k
C28 n28 0 10f
R29a vdd n29 10k
R29b n29 0 10k
C29 n29 0 10f
R30a vdd n30 10k
R30b n30 0 10k
C30 n30 0 10f
R31a vdd n31 10k
R31b n31 0 10k
C31 n31 0 10f
R32a vdd n32 10k
R32b n32 0 10k
C32 n32 0 10f
R33a vdd n33 10k
R33b n33 0 10k
C33 n33 0 10f
R34a vdd n34 10k
R34b n34 0 10k
C34 n34 0 10f
R35a vdd n35 10k
R35b n35 0 10k
C35 n35 0 10f
R36a vdd n36 10k
R36b n36 0 10k
C36 n36 0 10f
R37a vdd n37 10k
R37b n37 0 10k
C37 n37 0 10f
R38a vdd n38 10k
R38b n38 0 10k
C38 n38 0 10f
R39a vdd n39 10k
R39b n39 0 10k
C39 n39 0 10f
R40a vdd n40 10k
R40b n40 0 10k
C40 n40 0 10f
R41a vdd n41 10k
R41b n41 0 10k
C41 n41 0 10f
R42a vdd n42 10k
R42b n42 0 10k
C42 n42 0 10f
R43a vdd n43 10k
R43b n43 0 10k
C43 n43 0 10f
R44a vdd n44 10k
R44b n44 0 10k
C44 n44 0 10f
R45a vdd n45 10k
R45b n45 0 10k
C45 n45 0 10f
R46a vdd n46 10k
R46b n46 0 10k
C46 n46 0 10f
R47a vdd n47 10k
R47b n47 0 10k
C47 n47 0 10f
R48a vdd n48 10k
R48b n48 0 10k
C48 n48 0 10f
R49a vdd n49 10k
R49b n49 0 10k
C49 n49 0 10f
R50a vdd n50 10k
R50b n50 0 10k
C50 n50 0 10f
R51a vdd n51 10k
R51b n51 0 10k
C51 n51 0 10f
R52a vdd n52 10k
R52b n52 0 10k
C52 n52 0 10f
R53a vdd n53 10k
R53b n53 0 10k
C53 n53 0 10f
R54a vdd n54 10k
R54b n54 0 10k
C54 n54 0 10f
R55a vdd n55 10k
R55b n55 0 10k
C55 n55 0 10f
R56a vdd n56 10k
R56b n56 0 10k
C56 n56 0 10f
R57a vdd n57 10k
R57b n57 0 10k
C57 n57 0 10f
R58a vdd n58 10k
R58b n58 0 10k
C58 n58 0 10f
R59a vdd n59 10k
R59b n59 0 10k
C59 n59 0 10f
R60a vdd n60 10k
R60b n60 0 10k
C60 n60 0 10f
R61a vdd n61 10k
R61b n61 0 10k
C61 n61 0 10f
R62a vdd n62 10k
R62b n62 0 10k
C62 n62 0 10f
R63a vdd n63 10k
R63b n63 0 10k
C63 n63 0 10f
R64a vdd n64 10k
R64b n64 0 10k
C64 n64 0 10f
R65a vdd n65 10k
R65b n65 0 10k
C65 n65 0 10f
R66a vdd n66 10k
R66b n66 0 10k
C66 n66 0 10f
R67a vdd n67 10k
R67b n67 0 10k
C67 n67 0 10f
R68a vdd n68 10k
R68b n68 0 10k
C68 n68 0 10f
R69a vdd n69 10k
R69b n69 0 10k
C69 n69 0 10f
R70a vdd n70 10k
R70b n70 0 10k
C70 n70 0 10f
R71a vdd n71 10k
R71b n71 0 10k
C71 n71 0 10f
R72a vdd n72 10k
R72b n72 0 10k
C72 n72 0 10f
R73a vdd n73 10k
R73b n73 0 10k
C73 n73 0 10f
R74a vdd n74 10k
R74b n74 0 10k
C74 n74 0 10f
R75a vdd n75 10k
R75b n75 0 10k
C75 n75 0 10f
R76a vdd n76 10k
R76b n76 0 10k
C76 n76 0 10f
R77a vdd n77 10k
R77b n77 0 10k
C77 n77 0 10f
R78a vdd n78 10k
R78b n78 0 10k
C78 n78 0 10f
R79a vdd n79 10k
R79b n79 0 10k
C79 n79 0 10f
R80a vdd n80 10k
R80b n80 0 10k
C80 n80 0 10f
R81a vdd n81 10k
R81b n81 0 10k
C81 n81 0 10f
R82a vdd n82 10k
R82b n82 0 10k
C82 n82 0 10f
R83a vdd n83 10k
R83b n83 0 10k
C83 n83 0 10f
R84a vdd n84 10k
R84b n84 0 10k
C84 n84 0 10f
R85a vdd n85 10k
R85b n85 0 10k
C85 n85 0 10f
R86a vdd n86 10k
R86b n86 0 10k
C86 n86 0 10f
R87a vdd n87 10k
R87b n87 0 10k
C87 n87 0 10f
R88a vdd n88 10k
R88b n88 0 10k
C88 n88 0 10f
R89a vdd n89 10k
R89b n89 0 10k
C89 n89 0 10f
R90a vdd n90 10k
R90b n90 0 10k
C90 n90 0 10f
R91a vdd n91 10k
R91b n91 0 10k
C91 n91 0 10f
R92a vdd n92 10k
R92b n92 0 10k
C92 n92 0 10f
R93a vdd n93 10k
R93b n93 0 10k
C93 n93 0 10f
R94a vdd n94 10k
R94b n94 0 10k
C94 n94 0 10f
R95a vdd n95 10k
R95b n95 0 10k
C95 n95 0 10f
R96a vdd n96 10k
R96b n96 0 10k
C96 n96 0 10f
R97a vdd n97 10k
R97b n97 0 10k
C97 n97 0 10f
R98a vdd n98 10k
R98b n98 0 10k
C98 n98 0 10f
R99a vdd n99 10k
R99b n99 0 10k
C99 n99 0 10f
R100a vdd n100 10k
R100b n100 0 10k
C100 n100 0 10f
.tran 1n 80n
.end
