* RC ladder, N=100 stages
V1 in 0 PULSE(0 1 0 1n 1n 50n 100n)
R1 in n1 1k
C1 n1 0 1p
R2 n1 n2 1k
C2 n2 0 1p
R3 n2 n3 1k
C3 n3 0 1p
R4 n3 n4 1k
C4 n4 0 1p
R5 n4 n5 1k
C5 n5 0 1p
R6 n5 n6 1k
C6 n6 0 1p
R7 n6 n7 1k
C7 n7 0 1p
R8 n7 n8 1k
C8 n8 0 1p
R9 n8 n9 1k
C9 n9 0 1p
R10 n9 n10 1k
C10 n10 0 1p
R11 n10 n11 1k
C11 n11 0 1p
R12 n11 n12 1k
C12 n12 0 1p
R13 n12 n13 1k
C13 n13 0 1p
R14 n13 n14 1k
C14 n14 0 1p
R15 n14 n15 1k
C15 n15 0 1p
R16 n15 n16 1k
C16 n16 0 1p
R17 n16 n17 1k
C17 n17 0 1p
R18 n17 n18 1k
C18 n18 0 1p
R19 n18 n19 1k
C19 n19 0 1p
R20 n19 n20 1k
C20 n20 0 1p
R21 n20 n21 1k
C21 n21 0 1p
R22 n21 n22 1k
C22 n22 0 1p
R23 n22 n23 1k
C23 n23 0 1p
R24 n23 n24 1k
C24 n24 0 1p
R25 n24 n25 1k
C25 n25 0 1p
R26 n25 n26 1k
C26 n26 0 1p
R27 n26 n27 1k
C27 n27 0 1p
R28 n27 n28 1k
C28 n28 0 1p
R29 n28 n29 1k
C29 n29 0 1p
R30 n29 n30 1k
C30 n30 0 1p
R31 n30 n31 1k
C31 n31 0 1p
R32 n31 n32 1k
C32 n32 0 1p
R33 n32 n33 1k
C33 n33 0 1p
R34 n33 n34 1k
C34 n34 0 1p
R35 n34 n35 1k
C35 n35 0 1p
R36 n35 n36 1k
C36 n36 0 1p
R37 n36 n37 1k
C37 n37 0 1p
R38 n37 n38 1k
C38 n38 0 1p
R39 n38 n39 1k
C39 n39 0 1p
R40 n39 n40 1k
C40 n40 0 1p
R41 n40 n41 1k
C41 n41 0 1p
R42 n41 n42 1k
C42 n42 0 1p
R43 n42 n43 1k
C43 n43 0 1p
R44 n43 n44 1k
C44 n44 0 1p
R45 n44 n45 1k
C45 n45 0 1p
R46 n45 n46 1k
C46 n46 0 1p
R47 n46 n47 1k
C47 n47 0 1p
R48 n47 n48 1k
C48 n48 0 1p
R49 n48 n49 1k
C49 n49 0 1p
R50 n49 n50 1k
C50 n50 0 1p
R51 n50 n51 1k
C51 n51 0 1p
R52 n51 n52 1k
C52 n52 0 1p
R53 n52 n53 1k
C53 n53 0 1p
R54 n53 n54 1k
C54 n54 0 1p
R55 n54 n55 1k
C55 n55 0 1p
R56 n55 n56 1k
C56 n56 0 1p
R57 n56 n57 1k
C57 n57 0 1p
R58 n57 n58 1k
C58 n58 0 1p
R59 n58 n59 1k
C59 n59 0 1p
R60 n59 n60 1k
C60 n60 0 1p
R61 n60 n61 1k
C61 n61 0 1p
R62 n61 n62 1k
C62 n62 0 1p
R63 n62 n63 1k
C63 n63 0 1p
R64 n63 n64 1k
C64 n64 0 1p
R65 n64 n65 1k
C65 n65 0 1p
R66 n65 n66 1k
C66 n66 0 1p
R67 n66 n67 1k
C67 n67 0 1p
R68 n67 n68 1k
C68 n68 0 1p
R69 n68 n69 1k
C69 n69 0 1p
R70 n69 n70 1k
C70 n70 0 1p
R71 n70 n71 1k
C71 n71 0 1p
R72 n71 n72 1k
C72 n72 0 1p
R73 n72 n73 1k
C73 n73 0 1p
R74 n73 n74 1k
C74 n74 0 1p
R75 n74 n75 1k
C75 n75 0 1p
R76 n75 n76 1k
C76 n76 0 1p
R77 n76 n77 1k
C77 n77 0 1p
R78 n77 n78 1k
C78 n78 0 1p
R79 n78 n79 1k
C79 n79 0 1p
R80 n79 n80 1k
C80 n80 0 1p
R81 n80 n81 1k
C81 n81 0 1p
R82 n81 n82 1k
C82 n82 0 1p
R83 n82 n83 1k
C83 n83 0 1p
R84 n83 n84 1k
C84 n84 0 1p
R85 n84 n85 1k
C85 n85 0 1p
R86 n85 n86 1k
C86 n86 0 1p
R87 n86 n87 1k
C87 n87 0 1p
R88 n87 n88 1k
C88 n88 0 1p
R89 n88 n89 1k
C89 n89 0 1p
R90 n89 n90 1k
C90 n90 0 1p
R91 n90 n91 1k
C91 n91 0 1p
R92 n91 n92 1k
C92 n92 0 1p
R93 n92 n93 1k
C93 n93 0 1p
R94 n93 n94 1k
C94 n94 0 1p
R95 n94 n95 1k
C95 n95 0 1p
R96 n95 n96 1k
C96 n96 0 1p
R97 n96 n97 1k
C97 n97 0 1p
R98 n97 n98 1k
C98 n98 0 1p
R99 n98 n99 1k
C99 n99 0 1p
R100 n99 n100 1k
C100 n100 0 1p
.tran 1n 100n
.end
