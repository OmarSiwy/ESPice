// Current-controlled voltage source (ngspice H), incl. POLY(1).
//
// Port order is the netlist order: H<name> p n <vnam> <value>, with (cp,cn)
// standing in for `vnam`. ngspice takes the control current from a named
// V-source's branch unknown; a VA module has no cross-instance handle, so
// (cp,cn) is an explicit sense branch here and the netlist layer wires it in
// place of that V-source. `vsense` carries the replaced source's DC value so
// `V1 a b 5` + `H1 p n V1 100` keeps its 5 V (doc §1.5: the control quantity
// is that source's *branch unknown*, not a forced 0 V ammeter).
//
//   linear form   H... p n vnam <gain>            -> V = gain*I(sense)
//   POLY(1) form  H... p n vnam POLY(1) c0 c1 c2  -> V = c0 + c1*Ic + c2*Ic^2
// One polynomial covers both (doc §1.5 + §1.6): the netlist layer fills either
// `gain` or `c0..c2`, the unused set stays 0, so no mode flag. `gain` and `c1`
// are the same coefficient and add. `gain` defaults to 0 (ngspice has no
// default for H; VALUE is mandatory), so an omitted transresistance is inert.
//
// ponytail: one H/F consumer per `vnam` -- the sense branch is private to the
// instance, and two of them across the same node pair is a singular MNA row.
// Sharing one branch unknown between several consumers (doc §1.5, "sharing
// I_br,ctrl") has to happen host-side, not in this module. Same declared
// order-2/one-dimension POLY ceiling as vcvs/bsource (doc §1.6).
module ccvs(p, n, cp, cn);
    inout p, n, cp, cn;
    electrical p, n, cp, cn;
    branch (p, n) out;
    branch (cp, cn) sense;

    parameter real gain   = 0.0; // transresistance / POLY c1, V/A
    parameter real c0     = 0.0; // POLY(1) constant term, V
    parameter real c1     = 0.0; // POLY(1) linear term, V/A
    parameter real c2     = 0.0; // POLY(1) square term, V/A^2
    parameter real vsense = 0.0; // DC value of the replaced control V-source, V

    real k1;
    real ic;
    analog begin
        k1 = gain + c1;

        V(sense) <+ vsense;
        ic = I(sense);
        V(out) <+ c0 + k1 * ic + c2 * ic * ic;
    end
endmodule
