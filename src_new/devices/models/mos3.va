// MOS level 3 -- semi-empirical short-channel MOSFET (ngspice letter M, LEVEL=3).
//
// Spec: modules/devices/docs/mos-legacy.md S1.2 (channel block) + "Noise model"
// on the MOS1 chassis (docs/mos1-shichman-hodges.md S1.2-S1.8: parameter
// defaulting, temperature maps, series R, bulk junctions, Meyer gate caps,
// mode swap).
//
// Topology:   d --RD-- di --channel-- si --RS-- s
//             g --Meyer caps--> di, si, b        b --junction diodes--> di, si
//
// Everything above the "bias-dependent" marker is node-voltage independent
// (parameter prep, temperature, geometry) and folds at compile time.
//
// gm/gds/gmbs and every cap conductance come from differentiating the value
// chain (AD backend), so ngspice's d*/dv* bookkeeping is not transcribed; the
// one exception is gdsat in the CLM block, which ngspice writes in closed form.
// Limiting (fetlim/limvds/pnjlim, S1.7) is the solver's job.
module mos3(d, g, s, b);
    inout d, g, s, b;
    electrical d, g, s, b;
    electrical di, si;

    // --- polarity / gate material ---
    parameter integer dev_type = 1 from [-1:1] exclude 0;   // +1 NMOS, -1 PMOS
    parameter integer tpg = 1 from [-1:1];  // gate: +1 opp, -1 same, 0 aluminium

    // --- DC model parameters (ngspice names/defaults) ---
    parameter real vto    = 0.0;            // V      zero-bias threshold
    parameter real kp     = 2.07189e-5 from (0:inf);// A/V^2 transconductance
    parameter real gamma  = 0.0 from [0:inf);// sqrt(V) body effect
    parameter real phi    = 0.6 from (0:inf);// V     surface potential
    parameter real nsub   = 0.0 from [0:inf);// cm^-3 substrate doping
    parameter real nss    = 0.0 from [0:inf);// cm^-2 surface state density
    parameter real nfs    = 0.0 from [0:inf);// cm^-2 fast surface state density
    parameter real eta    = 0.0;            //        static feedback (DIBL)
    parameter real delta  = 0.0;            //        narrow-width factor
    parameter real theta  = 0.0;            // 1/V    mobility degradation
    parameter real kappa  = 0.2;            //        channel-length modulation
    parameter real u0     = 600.0 from (0:inf);// cm^2/Vs low-field mobility
    parameter real vmax   = 0.0 from [0:inf);// m/s   max drift velocity
    parameter real xj     = 0.0 from [0:inf);// m     junction depth
    parameter real xd     = 0.0 from [0:inf);// m/sqrt(V) depletion coeff (= sqrt(alpha))
    parameter real alpha  = 0.0 from [0:inf);// m^2/V  2*eps_si/(q*Nsub)
    parameter real delvto = 0.0;            // V      threshold adjust

    // --- geometry (ngspice DEFL/DEFW = 1e-4 m) ---
    parameter real l   = 1e-4 from (0:inf); // m  drawn length
    parameter real w   = 1e-4 from (0:inf); // m  drawn width
    parameter real ld  = 0.0;               // m  lateral diffusion
    parameter real xl  = 0.0;               // m  length mask adjust
    parameter real wd  = 0.0;               // m  width narrowing
    parameter real xw  = 0.0;               // m  width mask adjust
    parameter real tox = 1e-7 from (0:inf); // m  oxide thickness
    parameter real ad  = 0.0 from [0:inf);  // m^2 drain area
    parameter real as  = 0.0 from [0:inf);  // m^2 source area
    parameter real pd  = 0.0 from [0:inf);  // m   drain perimeter
    parameter real ps  = 0.0 from [0:inf);  // m   source perimeter
    parameter real m   = 1.0 from (0:inf);  //     parallel multiplier

    // --- series resistance ---
    parameter real rd  = 0.0 from [0:inf);  // Ohm
    parameter real rs  = 0.0 from [0:inf);  // Ohm
    parameter real rsh = 0.0 from [0:inf);  // Ohm/square
    parameter real nrd = 1.0 from [0:inf);  // squares, drain
    parameter real nrs = 1.0 from [0:inf);  // squares, source

    // --- bulk junctions ---
    parameter real is   = 1e-14 from [0:inf);// A     saturation current
    parameter real js   = 0.0 from [0:inf);  // A/m^2 saturation current density
    parameter real pb   = 0.8 from (0:inf);  // V     junction potential
    parameter real fc   = 0.5 from (0:1);    //       forward-bias cap factor
    parameter real cbd  = 0.0 from [0:inf);  // F
    parameter real cbs  = 0.0 from [0:inf);  // F
    parameter real cj   = 0.0 from [0:inf);  // F/m^2 bottom cap
    parameter real cjsw = 0.0 from [0:inf);  // F/m   sidewall cap
    parameter real mj   = 0.5 from (0:1);    //       bottom grading
    parameter real mjsw = 0.33 from (0:1);   //       sidewall grading
    parameter real gmin = 1e-12 from [0:inf);//  S    junction conductance floor

    // --- gate overlap caps ---
    parameter real cgso = 0.0 from [0:inf); // F/m
    parameter real cgdo = 0.0 from [0:inf); // F/m
    parameter real cgbo = 0.0 from [0:inf); // F/m

    // --- noise ---
    parameter real kf = 0.0 from [0:inf);   //     flicker coefficient
    parameter real af = 1.0 from (0:inf);   //     flicker exponent

    // --- temperature ---
    parameter real tnom  = 27.0;            // degC parameter measurement temp
    parameter real temp  = 27.0;            // degC explicit device temp override
    parameter real dtemp = 0.0;             // K    instance offset from $temperature

    // bias-independent prep
    real tk, tknom, vt, vtnom, vt300, ratio, eg, egnom, fact1, fact2;
    real pbfact1, pbfact, pbo, gmaold, gmanew, cfb, cfsw;
    real phinom, gammax, vtox, kpx, fermis, fermig, wkfng, wkfngs;
    real phit, sqphit, tpb, vbi;
    real ist, jst, cox, leff, weff, beta, u0t, kpt, fnarrow, etas, alph, xdw;
    real ldxj, xjleff, cscox, rdt, rst, gdser, gsser, cgsw, cgdw, cgbl;
    real cbse, cbde, cbssw, cbdsw, isats, isatd;
    // bias-dependent
    real vdsr, vgsr, vbsr, vgsm, vbsm, vdse, mode;
    real sarg, phibs, wps, wpxj, wcxj, arga, argb, argc, fshort;
    real gammas, fbody, qbonco, vbix, vth, xn, von, vgsx;
    real onfg, fgate, avds, vdsc, vdsat, vdsx, cdo, ids, fdrain;
    real gdsat, emax, delxl, clfact, gmch;
    real vbs, vbd, vgstm, vdsatm, cgsh, cgdh, cgbh, capgs, capgd, capgb;

    // Bulk junction current: MOS3's reverse branch is the (3Vt/(v*e))^3 form
    // (mos3load.c), not MOS1's flat -Isat; forward exp is clamped at
    // MAX_EXP_ARG = 709 so the derivative never dies on a live Newton step.
    analog function real jcur;
        input v, isat, vtx, gm;
        real v, isat, vtx, gm;
        real arg;
        begin
            if (v > -3.0 * vtx)
                jcur = isat * (exp(min(v / vtx, 709.0)) - 1.0) + gm * v;
            else begin
                arg = 3.0 * vtx / (v * 2.718281828459045);
                jcur = -isat * (1.0 + arg * arg * arg) + gm * v;
            end
        end
    endfunction

    // Junction depletion charge: power law below fc*pb(T), f1/f2/f3 quadratic
    // above (mos1temp.c forward-bias linearization). `pj` is the
    // temperature-mapped potential, so V_depcap = fc*pb(T) falls out.
    analog function real qjunc;
        input v, cj0, pj, mg, fcj;
        real v, cj0, pj, mg, fcj;
        real f1, f2, f3;
        begin
            if (cj0 <= 0.0) begin
                qjunc = 0.0;
            end else if (v < fcj * pj) begin
                qjunc = (cj0 * pj / (1.0 - mg)) *
                        (1.0 - pow(1.0 - v / pj, 1.0 - mg));
            end else begin
                f1 = (cj0 * pj / (1.0 - mg)) * (1.0 - pow(1.0 - fcj, 1.0 - mg));
                f2 = pow(1.0 - fcj, 1.0 + mg);
                f3 = 1.0 - fcj * (1.0 + mg);
                qjunc = f1 + (cj0 / f2) *
                        (f3 * (v - fcj * pj) +
                         (mg / (2.0 * pj)) * (v * v - fcj * fcj * pj * pj));
            end
        end
    endfunction

    analog begin
        // ================= bias-independent prep =========================
        // Device temperature is the simulator's plus the instance offset, unless
        // the instance gives TEMP explicitly (ngspice CKTtemp + dtemp rule).
        if ($param_given(temp)) tk = temp + 273.15;
        else tk = $temperature + dtemp;
        tknom = tnom + 273.15;
        vt    = 1.380649e-23 * tk / 1.602176634e-19;
        vtnom = 1.380649e-23 * tknom / 1.602176634e-19;
        vt300 = 1.380649e-23 * 300.15 / 1.602176634e-19;
        ratio = tk / tknom;
        fact1 = tknom / 300.15;
        fact2 = tk / 300.15;
        egnom = 1.16 - 7.02e-4 * tknom * tknom / (tknom + 1108.0);
        eg    = 1.16 - 7.02e-4 * tk * tk / (tk + 1108.0);
        // SPICE intrinsic shift (mos1temp.c): the bandgap terms are part of
        // pbfact, dropping them biases phi(T)/pb(T) by Eg(T) - r*Eg(Tnom).
        pbfact1 = -2.0 * vtnom * (1.5 * ln(fact1)
                  - egnom / (2.0 * vtnom) + 1.1150877 / (2.0 * vt300));
        pbfact  = -2.0 * vt * (1.5 * ln(fact2)
                  - eg / (2.0 * vt) + 1.1150877 / (2.0 * vt300));

        cox  = 3.9 * 8.8541878128e-12 / tox;        // F/m^2, oxideCapFactor
        leff = max(l - 2.0 * ld + xl, 1e-9);
        weff = max(w - 2.0 * wd + xw, 1e-9);

        // ---- S1.2 defaulting from NSUB (phi, gamma, then VTO via flat band).
        // "Given" is $param_given: every default here is also a legal card value.
        phinom = phi;
        gammax = gamma;
        vtox   = vto;
        if ($param_given(nsub) && nsub * 1e6 > 1.45e16) begin
            if (!$param_given(phi))
                phinom = max(0.1, 2.0 * vtnom * ln(nsub * 1e6 / 1.45e16));
            if (!$param_given(gamma))
                gammax = sqrt(2.0 * 11.7 * 8.8541878128e-12
                              * 1.602176634e-19 * nsub * 1e6) / cox;
            if (!$param_given(vto)) begin
                fermis = dev_type * 0.5 * phinom;
                if (tpg != 0) begin                 // poly gate
                    fermig = tpg * dev_type * 0.5 * egnom;
                    wkfng  = 3.25 + 0.5 * egnom - fermig;
                end else begin
                    wkfng  = 3.2;                   // aluminium gate
                end
                wkfngs = wkfng - (3.25 + 0.5 * egnom + fermis);
                vtox   = wkfngs - 1.602176634e-19 * nss * 1e4 / cox
                         + dev_type * (gammax * sqrt(phinom) + phinom);
            end
        end
        // KP is always Cox'-derived unless the card gives it (mos3temp.c).
        if ($param_given(kp)) kpx = kp; else kpx = u0 * cox * 1e-4;

        phit   = fact2 * (phinom - pbfact1) / fact1 + pbfact;
        sqphit = sqrt(phit);
        tpb    = fact2 * (pb - pbfact1) / fact1 + pbfact;

        kpt = kpx / pow(ratio, 1.5);
        u0t = u0 / pow(ratio, 1.5);
        ist = is * exp(-eg / vt + egnom / vtnom);
        jst = js * exp(-eg / vt + egnom / vtnom);

        // vbi(T) per mos1 chassis S1.3; DELVTO shifts VTO once, here.
        vbi  = vtox + delvto - dev_type * gammax * sqrt(phinom)
               + 0.5 * (egnom - eg) + dev_type * 0.5 * (phit - phinom);

        beta = kpt * weff / leff;

        fnarrow = delta * 3.14159265358979 * 11.7 * 8.8541878128e-12
                  / (2.0 * cox * weff);
        etas    = eta * 8.15e-22 / (cox * leff * leff * leff);

        // Depletion-layer coefficient: alpha = 2*eps_si/(q*Nsub) [Nsub in m^-3],
        // xd = sqrt(alpha); both are card-settable overrides (mos3.c).
        if ($param_given(alpha))
            alph = alpha;
        else if (nsub > 0.0)
            alph = 2.0 * 11.7 * 8.8541878128e-12
                   / (1.602176634e-19 * nsub * 1e6);
        else
            alph = 0.0;
        if ($param_given(xd)) xdw = xd; else xdw = sqrt(alph);

        // Dang short-channel sharing needs both xj and the depletion width.
        if (xj > 0.0 && xdw > 0.0) begin
            ldxj   = ld / xj;
            xjleff = xj / leff;
        end else begin
            ldxj   = 0.0;
            xjleff = 0.0;
        end

        if (nfs > 0.0)
            cscox = 1.602176634e-19 * nfs * 1e4 / cox;
        else
            cscox = 0.0;

        // Series R: explicit rd/rs, else sheet resistance x squares.
        rdt = rd;
        if (rdt <= 0.0) rdt = rsh * nrd;
        rst = rs;
        if (rst <= 0.0) rst = rsh * nrs;
        if (rdt > 0.0) gdser = m / rdt; else gdser = 0.0;
        if (rst > 0.0) gsser = m / rst; else gsser = 0.0;

        cgsw = cgso * weff * m;
        cgdw = cgdo * weff * m;
        cgbl = cgbo * leff * m;

        // Junction caps: absolute CBD/CBS if given, else CJ*area (+ CJSW*perim),
        // all through the two-stage 1+MJ(4e-4 dT - gamma_ma) temperature factor.
        pbo    = (pb - pbfact1) / fact1;
        gmaold = (pb - pbo) / pbo;
        gmanew = (tpb - pbo) / pbo;
        cfb    = (1.0 + mj * (4e-4 * (tk - 300.15) - gmanew))
                 / (1.0 + mj * (4e-4 * (tknom - 300.15) - gmaold));
        cfsw   = (1.0 + mjsw * (4e-4 * (tk - 300.15) - gmanew))
                 / (1.0 + mjsw * (4e-4 * (tknom - 300.15) - gmaold));

        if (cbs > 0.0) cbse = cbs * cfb * m; else cbse = cj * cfb * as * m;
        if (cbd > 0.0) cbde = cbd * cfb * m; else cbde = cj * cfb * ad * m;
        cbssw = cjsw * cfsw * ps * m;
        cbdsw = cjsw * cfsw * pd * m;

        // JS wins only when BOTH areas are given: ngspice decides once for the
        // pair (mos3load.c), not per junction.
        if (js > 0.0 && ad > 0.0 && as > 0.0) begin
            isats = jst * as * m;
            isatd = jst * ad * m;
        end else begin
            isats = ist * m;
            isatd = ist * m;
        end

        // ================= series resistance branches =====================
        // R = 0 collapses the prime node onto the port (ngspice MOS3setup).
        if (gdser > 0.0)
            I(d, di) <+ gdser * V(d, di)
                        + white_noise(4.0 * 1.380649e-23 * tk * gdser, "rd");
        else
            V(d, di) <+ 0.0;

        if (gsser > 0.0)
            I(s, si) <+ gsser * V(s, si)
                        + white_noise(4.0 * 1.380649e-23 * tk * gsser, "rs");
        else
            V(s, si) <+ 0.0;

        // ================= bias-dependent: channel ========================
        vdsr = dev_type * V(di, si);
        vgsr = dev_type * V(g, si);
        vbsr = dev_type * V(b, si);

        // Mode swap: reversed device runs the same algebra with d/s exchanged.
        if (vdsr >= 0.0) begin
            mode = 1.0;
            vgsm = vgsr;
            vbsm = vbsr;
        end else begin
            mode = -1.0;
            vgsm = vgsr - vdsr;
            vbsm = vbsr - vdsr;
        end
        vdse = mode * vdsr;

        // Body-bias square root (Taylor form for forward bias keeps it real).
        if (vbsm <= 0.0)
            sarg = sqrt(phit - vbsm);
        else
            sarg = sqphit / (1.0 + vbsm / (phit + phit));
        phibs = sarg * sarg;

        // Dang short-channel depletion-sharing factor fs.
        if (xjleff > 0.0) begin
            wps  = xdw * sarg;
            wpxj = wps / xj;
            wcxj = 0.0631353 + 0.8013292 * wpxj - 0.01110777 * wpxj * wpxj;
            arga = wcxj + ldxj;
            argc = wpxj / (1.0 + wpxj);
            argb = sqrt(max(1.0 - argc * argc, 0.0));
            fshort = 1.0 - xjleff * (arga * argb - ldxj);
        end else begin
            fshort = 1.0;
        end

        // Body effect + narrow width -> threshold.
        gammas = gammax * fshort;
        fbody  = gammas / (4.0 * sarg) + fnarrow;
        qbonco = gammas * sarg + fnarrow * phibs;
        vbix   = dev_type * vbi - etas * vdse;
        vth    = vbix + qbonco;

        // Weak-inversion slope from NFS.
        if (nfs > 0.0) begin
            xn  = 1.0 + cscox + qbonco / (2.0 * phibs);
            von = vth + xn * vt;
        end else begin
            xn  = 1.0;
            von = vth;
        end
        vgsx = max(vgsm, von);

        // Mobility: gate-field degradation, then velocity saturation Vdsat.
        onfg  = max(1.0 + theta * (vgsx - vth), 1e-30);
        fgate = 1.0 / onfg;
        avds  = (vgsx - vth) / (1.0 + fbody);
        if (vmax > 0.0) begin
            vdsc  = leff * vmax * onfg / (u0t * 1e-4);
            vdsat = avds + vdsc - sqrt(avds * avds + vdsc * vdsc);
        end else begin
            vdsc  = 0.0;
            vdsat = avds;
        end

        vdsx = min(vdse, max(vdsat, 0.0));
        cdo  = vgsx - vth - 0.5 * (1.0 + fbody) * vdsx;
        ids  = beta * fgate * cdo * vdsx;
        if (vmax > 0.0) begin
            fdrain = 1.0 / (1.0 + vdsx / max(vdsc, 1e-30));
            ids = ids * fdrain;
        end else begin
            fdrain = 1.0;
        end

        // Channel-length modulation (mos3load.c, KAPPA + punch through); needs
        // the depletion coefficient, i.e. NSUB or ALPHA given.  Two deltas vs
        // the naive form: with VMAX the saturation field emax sets the offset,
        // and the default (badMos3 = 0) delta-L carries the vdsat/8 offset plus
        // a sub-vdsat (vds/vdsat)^4 ramp so delta-L -- hence gds -- is
        // continuous through vdsat instead of having an infinite slope there.
        if (alph > 0.0 && kappa > 0.0) begin
            if (vdse > vdsat) begin
                if (vmax > 0.0) begin
                    // ids == cdsat here (vdsx was clamped to vdsat).
                    gdsat = max(1e-12, ids * (1.0 - fdrain) / max(vdsc, 1e-30));
                    emax  = kappa * ids / (leff * gdsat);
                    arga  = 0.5 * emax * alph;
                    delxl = sqrt(arga * arga + kappa * alph * (vdse - vdsat))
                            - arga;
                end else begin
                    delxl = sqrt(kappa * alph * (vdse - vdsat + 0.125 * vdsat));
                end
            end else if (vdsat > 0.0) begin
                delxl = sqrt(0.125 * kappa * alph * vdsat)
                        * pow(vdse / vdsat, 4.0);
            end else begin
                delxl = 0.0;
            end
            if (delxl > 0.5 * leff)
                delxl = leff - leff * leff / (4.0 * delxl);
            clfact = 1.0 - delxl / leff;
            ids = ids / clfact;
        end

        // Weak inversion: exponential below von (NFS), hard cutoff without it.
        if (nfs > 0.0)
            ids = ids * exp(min((vgsm - von) / (xn * vt), 0.0));
        else if (vgsm <= von)
            ids = 0.0;

        I(di, si) <+ dev_type * m * mode * ids;

        // ================= bulk junction diodes ===========================
        vbs = dev_type * V(b, si);
        vbd = dev_type * V(b, di);
        I(b, si) <+ dev_type * jcur(vbs, isats, vt, gmin);
        I(b, di) <+ dev_type * jcur(vbd, isatd, vt, gmin);

        // ================= charges: junctions + Meyer gate =================
        I(b, si) <+ dev_type * ddt(qjunc(vbs, cbse, tpb, mj, fc)
                                   + qjunc(vbs, cbssw, tpb, mjsw, fc));
        I(b, di) <+ dev_type * ddt(qjunc(vbd, cbde, tpb, mj, fc)
                                   + qjunc(vbd, cbdsw, tpb, mjsw, fc));

        // Meyer caps, DEVqmeyer verbatim (mos1 doc S1.6) in the swapped frame
        // with the channel block's own von/vdsat -- not a private threshold --
        // and Vdsat' = max(Vdsat, MAGIC_VDS = 0.025), which is what bounds the
        // near-threshold split.  DEVqmeyer returns half the non-constant part
        // and the load routine sums two timepoint halves, so 2*half + overlap
        // is the OP-consistent total.  Meyer caps are capacitance-based
        // (q advanced as C*dv), i.e. C(v)*ddt(V) here -- not charge conserving,
        // matching ngspice.
        vgstm  = vgsm - von;
        vdsatm = max(vdsat, 0.025);
        if (vgstm <= -phit) begin                   // accumulation
            cgbh = 0.5 * cox * weff * leff * m;
            cgsh = 0.0;
            cgdh = 0.0;
        end else if (vgstm <= -0.5 * phit) begin    // depletion
            cgbh = -vgstm * cox * weff * leff * m / (2.0 * phit);
            cgsh = 0.0;
            cgdh = 0.0;
        end else if (vgstm <= 0.0) begin            // weak inversion
            cgbh = -vgstm * cox * weff * leff * m / (2.0 * phit);
            cgsh = vgstm * cox * weff * leff * m / (1.5 * phit)
                   + cox * weff * leff * m / 3.0;
            cgdh = 0.0;
        end else if (vdsatm <= vdse) begin          // saturation
            cgbh = 0.0;
            cgsh = cox * weff * leff * m / 3.0;
            cgdh = 0.0;
        end else begin                              // linear
            cgbh = 0.0;
            argb = 2.0 * vdsatm - vdse;
            arga = vdsatm - vdse;
            cgdh = (cox * weff * leff * m / 3.0)
                   * (1.0 - vdsatm * vdsatm / (argb * argb));
            cgsh = (cox * weff * leff * m / 3.0)
                   * (1.0 - arga * arga / (argb * argb));
        end
        // Inverted mode: qmeyer ran swapped, so swap its cgs/cgd back.
        if (mode > 0.0) begin
            capgs = 2.0 * cgsh + cgsw;
            capgd = 2.0 * cgdh + cgdw;
        end else begin
            capgs = 2.0 * cgdh + cgsw;
            capgd = 2.0 * cgsh + cgdw;
        end
        capgb = 2.0 * cgbh + cgbl;

        I(g, si) <+ capgs * ddt(V(g, si));
        I(g, di) <+ capgd * ddt(V(g, di));
        I(g, b)  <+ capgb * ddt(V(g, b));

        // ================= noise (mos-legacy.md noise table) ==============
        // gm comes from the same AD machinery as the Jacobian instead of a
        // hand-differentiated second copy of the channel chain.
        gmch = m * abs(ddx(ids, V(g)));
        I(di, si) <+ white_noise(4.0 * 1.380649e-23 * tk * (2.0 / 3.0) * gmch,
                                 "channel");
        if (kf > 0.0)
            I(di, si) <+ flicker_noise(kf * pow(abs(m * ids), af)
                                       / (weff * m * leff * cox * cox),
                                       1.0, "flicker");
    end
endmodule
