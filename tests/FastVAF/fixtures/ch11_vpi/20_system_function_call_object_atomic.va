module ch11_system_function_call_object_atomic(p, n);
  inout p, n; electrical p, n;
  analog I(p,n) <+ $fixture_vpi_function_object(V(p,n));
endmodule
