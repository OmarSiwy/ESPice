module ch11_parameters_variables(p, n);
  inout p, n; electrical p, n;
  parameter real gain = 2.0;
  integer mode;
  real result;
  analog begin
    mode = 1;
    result = gain*V(p,n);
    I(p,n) <+ result + mode;
  end
endmodule
