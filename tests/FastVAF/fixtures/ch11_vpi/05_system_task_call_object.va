module ch11_system_task_call_object(p, n);
  inout p, n; electrical p, n;
  analog begin
    $fixture_vpi_task(V(p,n));
    I(p,n) <+ V(p,n);
  end
endmodule
