module ch11_process_statement_objects(p, n);
  inout p, n; electrical p, n;
  integer k;
  real result;
  analog begin : process_block
    result = 0.0;
    for (k=0; k<3; k=k+1) result = result + V(p,n);
    if (result > 0.0) result = result + 1.0;
    else result = result - 1.0;
    case (k)
      3: result = result + 3.0;
      default: result = 0.0;
    endcase
    I(p,n) <+ result;
  end
endmodule
