`include "disciplines.vams"
module ch11_nature_discipline_objects(p, n);
  inout p, n; electrical p, n;
  analog I(p,n) <+ V(p,n);
endmodule
