module ch11_conditional_case_objects(p, n);
  inout p, n; electrical p, n;
  integer mode; real result;
  analog begin
    mode = (V(p,n) > 0.0);
    if (mode) result = V(p,n); else result = -V(p,n);
    case (mode)
      1: result = result + 1.0;
      default: result = result - 1.0;
    endcase
    I(p,n) <+ result;
  end
endmodule
