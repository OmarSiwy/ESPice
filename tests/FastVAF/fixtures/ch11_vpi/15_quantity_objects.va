module ch11_quantity_objects(p, n);
  inout p, n; electrical p, n;
  branch (p,n) path;
  real v_value, i_value;
  analog begin
    v_value = V(path);
    i_value = I(path);
    I(path) <+ v_value / 1k + i_value * 0.0;
  end
endmodule
