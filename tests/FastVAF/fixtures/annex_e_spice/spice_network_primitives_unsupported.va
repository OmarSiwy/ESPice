// EXPECT: error -- SPICE objects require hierarchy/SPICE elaboration.
module annex_e_spice_network_primitives_unsupported(p, n);
  inout p, n; electrical p, n;
  vcvs #(.gain(2.0)) e1(p, n, p, n);
endmodule
