`define PHYSICAL_CONSTANTS_SPICE 1
// Both lower-priority selectors are set: SPICE must still win.
`define PHYSICAL_CONSTANTS_OLD 1
`define PHYSICAL_CONSTANTS_NIST2010 1
`include "physical_constants_select.vh"
module annex_d_spice_constants(p);
  inout p; electrical p;
  analog I(p) <+ `P_Q + `P_K + `P_H + `P_EPS0 + `P_U0 + 0.0*V(p);
endmodule
