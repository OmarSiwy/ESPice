nature Angle;
  units = "rads";
  access = Theta;
  ddt_nature = Angular_Velocity;
  abstol = 1e-6;
endnature
nature Angular_Velocity;
  units = "rads/s";
  access = Omega;
  ddt_nature = Angular_Acceleration;
  idt_nature = Angle;
  abstol = 1e-6;
endnature
nature Angular_Acceleration;
  units = "rads/s^2";
  access = Alpha;
  idt_nature = Angular_Velocity;
  abstol = 1e-6;
endnature
nature Angular_Force;
  units = "N*m";
  access = Tau;
  abstol = 1e-6;
endnature
discipline rotational_d;
  potential Angle;
  flow Angular_Force;
enddiscipline
discipline rotational_omega_d;
  potential Angular_Velocity;
  flow Angular_Force;
enddiscipline
module annex_d_rotational;
  electrical p;
  analog I(p) <+ V(p);
endmodule
