// EXPECT: error
module ch12_atomic_mcd_printf(p, n);
  inout p, n; electrical p, n;
  analog I(p,n) <+ vpi_mcd_printf(0);
endmodule
