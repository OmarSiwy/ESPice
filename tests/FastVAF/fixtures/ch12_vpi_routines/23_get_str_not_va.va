// EXPECT: error
module ch12_atomic_get_str(p, n);
  inout p, n; electrical p, n;
  analog I(p,n) <+ vpi_get_str(0);
endmodule
