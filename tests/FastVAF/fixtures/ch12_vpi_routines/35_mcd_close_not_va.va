// EXPECT: error
module ch12_atomic_mcd_close(p, n);
  inout p, n; electrical p, n;
  analog I(p,n) <+ vpi_mcd_close(0);
endmodule
