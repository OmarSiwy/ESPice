// EXPECT: error
module ch12_sim_control_not_va(p, n);
  inout p, n; electrical p, n;
  analog I(p,n) <+ vpi_sim_control(1);
endmodule
