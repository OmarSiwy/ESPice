nature annex_f_voltage;
  units = "V";
  access = V;
  abstol = 1u;
endnature
nature annex_f_current;
  units = "A";
  access = I;
  abstol = 1p;
endnature
discipline annex_f_continuous;
  potential annex_f_voltage;
  flow annex_f_current;
  domain continuous;
enddiscipline
module annex_f_cont(p);
  inout p; annex_f_continuous p;
  analog I(p) <+ V(p);
endmodule
