module ch04_greater_than(p, n); inout p, n; electrical p, n; analog I(p, n) <+ (V(p, n) > 1.0); endmodule
