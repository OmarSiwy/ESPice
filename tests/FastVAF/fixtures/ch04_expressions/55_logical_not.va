module ch04_logical_not(p, n); inout p, n; electrical p, n; analog I(p, n) <+ !(V(p, n) == 0.0); endmodule
