module ch04_ceil(p, n); inout p, n; electrical p, n; analog I(p, n) <+ ceil(V(p, n)); endmodule
