module ch04_ddx(p, n);
    inout p, n;
    electrical p, n;
    real current_value, conductance;

    analog begin
        current_value = limexp(V(p, n)) - 1.0;
        conductance = ddx(current_value, V(p));
        I(p, n) <+ current_value + conductance;
    end
endmodule
