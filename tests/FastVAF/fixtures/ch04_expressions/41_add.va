module ch04_add(p, n); inout p, n; electrical p, n; analog I(p, n) <+ V(p, n) + 2.0; endmodule
