module ch04_bitwise_xnor(p, n); inout p, n; electrical p, n; integer a; analog begin a = 5 ~^ 3; I(p, n) <+ a; end endmodule
