module ch4_same_flow(p); inout p; electrical p; analog I(p,p)<+1m; endmodule
