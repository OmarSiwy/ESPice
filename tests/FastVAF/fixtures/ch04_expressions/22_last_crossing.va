module ch04_last_crossing(p, n);
    inout p, n;
    electrical p, n;
    real crossing_time;

    analog begin
        crossing_time = last_crossing(V(p, n), 1);
        I(p, n) <+ crossing_time;
    end
endmodule
