module ch04_unary_plus(p, n); inout p, n; electrical p, n; analog I(p, n) <+ +V(p, n); endmodule
