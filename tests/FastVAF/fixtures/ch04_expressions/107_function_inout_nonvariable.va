module ch4_fn_inout_actual(p); inout p; electrical p; real dummy; analog function real f; inout x; real x; begin x=x+1.0; f=x; end endfunction analog begin dummy=f(V(p)); I(p)<+dummy; end endmodule
