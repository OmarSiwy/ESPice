module ch04_max(p, n); inout p, n; electrical p, n; analog I(p, n) <+ max(V(p, n), 1.0); endmodule
