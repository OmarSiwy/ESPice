module ch04_sinh(p, n); inout p, n; electrical p, n; analog I(p, n) <+ sinh(V(p, n)); endmodule
