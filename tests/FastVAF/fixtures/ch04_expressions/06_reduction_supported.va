module ch04_reduction_supported(p, n);
    inout p, n;
    electrical p, n;
    integer bits, value;

    analog begin
        bits = 15;
        value = |bits;
        value = value + &bits + ~|bits + ~&bits;
        I(p, n) <+ value;
    end
endmodule
