// §5.9.3: "The analog_for statements are syntactically equivalent to for()
// statements except the associated analog statement can contain analog
// operators." The genvar form unrolls onto the spine at elaboration, so every
// `ddt` instance is stepped on every evaluation and none of them can miss a
// timestep. This is the LEGAL counterpart of 89/90/91 and must keep compiling —
// it is what proves E0514 rejects the construct and not the shape.
module ch4_op_genvar_for(p);
  inout p;
  electrical p;
  genvar i;
  real x;
  analog begin
    x = 0.0;
    for (i = 0; i < 2; i = i + 1) x = x + ddt(V(p));
    I(p) <+ x;
  end
endmodule
