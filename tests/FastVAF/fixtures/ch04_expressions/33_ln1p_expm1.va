// ln1p() is defined only for x > -1 (LRM 4.3.1 Table 4-14) and expm1()
// overflows for large x; a node voltage is unbounded, so both are guarded.
module ch04_ln1p_expm1(p, n);
  inout p, n; electrical p, n;

  analog begin
    if (V(p, n) > -1.0)
      if (V(p, n) < 100.0)
        I(p, n) <+ ln1p(V(p, n)) + expm1(V(p, n));
  end
endmodule
