module ch04_function_output_inout(p, n);
    inout p, n;
    electrical p, n;
    real area, perimeter, value;

    analog function real geometry;
        input real length, width;
        output real result_area, result_perimeter;
        inout real accumulator;
        begin
            result_area = length * width;
            result_perimeter = 2.0 * (length + width);
            accumulator = accumulator + result_area;
            geometry = accumulator;
        end
    endfunction

    analog begin
        value = geometry(V(p, n), 2.0, area, perimeter, value);
        I(p, n) <+ value + area + perimeter;
    end
endmodule
