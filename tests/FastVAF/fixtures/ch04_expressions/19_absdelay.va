module ch04_absdelay(p, n);
    inout p, n;
    electrical p, n;

    analog V(p, n) <+ absdelay(I(p, n), 1n);
endmodule
