// asin() is defined only for -1 <= x <= 1 (LRM 4.3.2 Table 4-15); a node
// voltage is unbounded, so the call is guarded into that domain.
module ch04_asin(p, n);
  inout p, n; electrical p, n;
  analog begin
    if (V(p, n) >= -1.0)
      if (V(p, n) <= 1.0)
        I(p, n) <+ asin(V(p, n));
  end
endmodule
