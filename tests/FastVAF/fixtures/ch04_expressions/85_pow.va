module ch04_pow(p, n); inout p, n; electrical p, n; analog I(p, n) <+ pow(abs(V(p, n)) + 1.0, 2.0); endmodule
