module ch04_log10(p, n); inout p, n; electrical p, n; analog I(p, n) <+ log(abs(V(p, n)) + 1.0); endmodule
