module ch04_atan(p, n); inout p, n; electrical p, n; analog I(p, n) <+ atan(V(p, n)); endmodule
