module ch04_noise_sources(p, n);
    inout p, n;
    electrical p, n;
    parameter real resistance = 1000.0 from (0:inf);

    analog begin
        I(p, n) <+ white_noise(4.0 * 1.380649e-23 * $temperature / resistance, "thermal");
        I(p, n) <+ flicker_noise(1e-20, 1.0, "flicker");
        I(p, n) <+ noise_table('{1.0, 1e-18, 1e6, 1e-24}, "linear-table");
        I(p, n) <+ noise_table_log('{1.0, 1e-18, 1e6, 1e-24}, "log-table");
    end
endmodule
