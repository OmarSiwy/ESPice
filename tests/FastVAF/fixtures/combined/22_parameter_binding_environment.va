module combined_parameter_binding_environment(p, n, aux);
  inout p, n, aux; electrical p, n, aux;
  parameter real gain = 1.0 from [0:inf);
  parameter real fallback = 0.5;
  real effective;
  analog begin
    effective = $param_given(gain) ? gain : fallback;
    if ($port_connected(aux)) effective = effective + V(aux,n);
    I(p,n) <+ effective * V(p,n);
  end
endmodule
