`include "constants.vams"
module combined_noise_temperature_analysis(p, n);
  inout p, n; electrical p, n;
  parameter real resistance = 10k from (0:inf);
  parameter real flicker_coefficient = 1e-20 from [0:inf);
  analog begin
    I(p,n) <+ V(p,n) / resistance;
    if (analysis("noise")) begin
      I(p,n) <+ white_noise(4.0 * `P_K * $temperature / resistance, "thermal");
      I(p,n) <+ flicker_noise(flicker_coefficient, 1.0, "flicker");
    end
  end
endmodule
