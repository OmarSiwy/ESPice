module combined_loop_case_system_message(p, n);
  inout p, n; electrical p, n;
  integer k;
  real sum, d;
  analog begin
    sum = 0.0;
    // The loop bound is not carried into the divisor, so guard it explicitly
    // (LRM 4.2.4 leaves division by zero undefined).
    for (k=0; k<4; k=k+1) begin
      d = k + 1;
      if (d != 0.0) sum = sum + V(p,n)/d;
    end
    case (k)
      4: $strobe("sum=%g at %g", sum, $abstime);
      default: $warning("unexpected loop count");
    endcase
    I(p,n) <+ sum;
  end
endmodule
