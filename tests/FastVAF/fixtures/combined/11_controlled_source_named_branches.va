module combined_controlled_source_named_branches(outp, outn, cp, cn);
  inout outp, outn, cp, cn;
  electrical outp, outn, cp, cn;
  branch (cp, cn) control;
  branch (outp, outn) output_path;
  parameter real gm = 1m from [0:inf);
  analog begin
    I(output_path) <+ gm * V(control);
    I(control) <+ V(control) / 1G;
  end
endmodule
