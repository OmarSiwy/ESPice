module ch6_generate_direct_nesting(p);
  inout p; electrical p;
  parameter integer first = 0, second = 1;
  generate
    if (first) begin : selected
      I(p) <+ V(p);
    end else if (second) begin : selected
      I(p) <+ 2.0 * V(p);
    end else begin : selected
      I(p) <+ 0.0;
    end
  endgenerate
endmodule
