module ch6_output(output electrical p); analog V(p)<+1.0; endmodule
