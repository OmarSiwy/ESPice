module ch6_input(input electrical p); analog I(p)<+V(p); endmodule
