module ch6_top;
  electrical p;
  analog V(p) <+ 1.0;
endmodule
