// EXPECT: error
module module;
endmodule
