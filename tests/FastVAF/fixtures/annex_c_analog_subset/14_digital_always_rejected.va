// EXPECT: error
module annex_c_digital_always_rejected;
    integer state;
    always state = !state;
endmodule
