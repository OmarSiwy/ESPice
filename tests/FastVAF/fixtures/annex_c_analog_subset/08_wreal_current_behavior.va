module annex_c_wreal_current_behavior;
    wreal real_signal;
endmodule
