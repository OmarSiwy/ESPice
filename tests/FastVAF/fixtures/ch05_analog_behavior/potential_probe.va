module ch5_potential_probe(p, n);
  inout p, n; electrical p, n;
  analog I(p, n) <+ V(p, n) / 1000.0;
endmodule
