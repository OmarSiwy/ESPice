module ch5_while_false(p); inout p; electrical p; integer i; analog begin i=0; while(i<0) i=i+1; I(p)<+i; end endmodule
