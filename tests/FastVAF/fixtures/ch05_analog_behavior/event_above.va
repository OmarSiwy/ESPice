module ch5_above(p, c);
  inout p, c; electrical p, c; real held;
  analog begin
    @(above(V(c) - 0.5, 1p)) held = V(p);
    I(p) <+ held;
  end
endmodule
