module ch5_repeat_one(p); inout p; electrical p; real x; analog begin x=0.0; repeat(1) x=x+V(p); I(p)<+x; end endmodule
