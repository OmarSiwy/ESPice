module ch5_multiple_indirect(p, n, c1, c2);
  inout p, n, c1, c2; electrical p, n, c1, c2;
  analog begin
    V(p, n) : V(c1) == V(p, n);
    V(p, n) : V(c2) == 2.0 * V(p, n);
  end
endmodule
