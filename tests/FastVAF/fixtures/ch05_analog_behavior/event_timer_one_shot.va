module ch5_timer_once(p); inout p; electrical p; real x; analog begin @(timer(1n,0.0)) x=1.0; I(p)<+x+0.0*V(p); end endmodule
