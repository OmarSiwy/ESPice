module ch5_access_two(p, n);
  inout p, n; electrical p, n;
  analog I(p, n) <+ V(p, n);
endmodule
