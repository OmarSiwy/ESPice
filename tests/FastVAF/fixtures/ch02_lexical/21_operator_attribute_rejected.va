// Annex A.8.3 allows `{ attribute_instance }` after a binary operator (LRM
// 2.9.1), so this must COMPILE despite the historical `_rejected` file name.
module ch02_operator_attribute_rejected;
    real value;
    analog value = 1.0 + (* mode = "cla" *) 2.0;
endmodule
