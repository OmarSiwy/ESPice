// §4.2.8 bitwise and §4.2.11 shift operators. Integer-only (§3.2), and the
// right shift of a NEGATIVE value is the interesting case.
//
// §4.2.11: "Both the << and >> shift operators fill the vacated bit positions
// with zeroes (0). The right operand is always treated as an unsigned number
// and has no effect on the signedness of the result." So `>>` is a LOGICAL
// shift, and a zero fill only means something against a width — §3.2.1 fixes
// the Verilog-A `integer` at 32 bits.
//
// This file used to assert `-16 >> 2 == -4`, i.e. the C/Zig arithmetic shift.
// That was FastVAF's own behaviour written down as if it were the rule, which
// is exactly the failure mode a transcript suite exists to prevent — a `want`
// column is only an oracle when it was derived from the standard.
//
//! print none
`include "check.vh"
module ex023_bitwise_shift(p, n);
  inout p, n;
  electrical p, n;
  analog begin
    `CHECKI("and", 12 & 10, 8);
    `CHECKI("or", 12 | 10, 14);
    `CHECKI("xor", 12 ^ 10, 6);
    `CHECKI("not", ~0, -1);
    `CHECKI("xnor", 12 ~^ 10, -7);
    `CHECKI("shl", 3 << 4, 48);
    `CHECKI("shr", 48 >> 4, 3);
    // 0xFFFFFFF0 >> 2 == 0x3FFFFFFC. The sign is NOT propagated.
    `CHECKI("shr zero-fills a negative, over a 32-bit integer", -16 >> 2, 1073741820);
    `CHECKI("shr zero-fills -1 to the whole mask", -1 >> 1, 2147483647);
    // `>>>`/`<<<` are annex-C rejections, not gaps: the analog subset has no
    // arithmetic shift. Pinned as an expected diagnostic in
    // tests/fixtures/annex_c_analog_subset, not here.
    I(p, n) <+ 0.0;
  end
endmodule
