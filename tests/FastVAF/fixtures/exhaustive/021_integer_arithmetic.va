// §3.2 integers and §4.2.4 integer arithmetic. Division TRUNCATES toward zero
// and `%` takes the sign of the left operand — the two places where an
// implementation that reached for the nearest floating-point op would be wrong.
//
//! print none
`include "check.vh"
module ex021_integer_arithmetic(p, n);
  inout p, n;
  electrical p, n;
  analog begin
    `CHECKI("add", 7 + 5, 12);
    `CHECKI("sub", 7 - 5, 2);
    `CHECKI("mul", 7 * 5, 35);
    `CHECKI("div truncates toward zero", 7 / 2, 3);
    `CHECKI("div negative truncates toward zero", -7 / 2, -3);
    `CHECKI("mod takes sign of lhs", 7 % 3, 1);
    `CHECKI("mod negative lhs", -7 % 3, -1);
    // KNOWN GAP: `7 % -3` is rejected by proof.zig with E0601 "divisor cannot
    // be proven non-zero" — a negated integer literal loses its constant range,
    // so a divisor the LRM makes obviously nonzero looks unbounded. The rule
    // (§4.2.4: the result takes the sign of the LEFT operand) is covered by the
    // two lines above; add the third when the prover folds unary minus.
    `CHECKI("unary minus", -7, -7);
    `CHECKI("abs", abs(-7), 7);
    `CHECKI("min", min(7, 5), 5);
    `CHECKI("max", max(7, 5), 7);
    I(p, n) <+ 0.0;
  end
endmodule
