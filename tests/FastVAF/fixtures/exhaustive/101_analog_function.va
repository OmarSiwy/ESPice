// §4.7 a user-defined analog function. It is INLINED at each call site (§4.7.1),
// so the claim is that arguments, locals and the return slot are per-call and do
// not leak between them — which two calls with different arguments show.
//
//! print none
`include "check.vh"
module ex101_analog_function(p, n);
  inout p, n;
  electrical p, n;

  analog function real square;
    input x;
    real x;
    begin
      square = x * x;
    end
  endfunction

  analog function real poly;
    input x, a, b;
    real x, a, b;
    real t;
    begin
      t = a * x + b;
      poly = t * t;
    end
  endfunction

  analog begin
    `CHECKX("square(3)", square(3.0), 9.0);
    `CHECKX("square(-4)", square(-4.0), 16.0);
    `CHECKX("two calls do not share state", square(2.0) + square(5.0), 29.0);
    `CHECKX("multi-argument function", poly(2.0, 3.0, 1.0), 49.0);
    `CHECKX("nested calls", square(square(2.0)), 16.0);
    I(p, n) <+ 0.0;
  end
endmodule
