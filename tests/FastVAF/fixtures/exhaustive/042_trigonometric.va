// §4.3.2 trigonometric functions and their inverses. `tan`, `asin`, `acos` are
// COMPOSED by codegen (sin/cos, atan of a radical) rather than emitted as
// primitives, so their agreement with libm is a real claim, not a pass-through.
//
//! print none
`include "check.vh"
module ex042_trigonometric(p, n);
  inout p, n;
  electrical p, n;
  analog begin
    `CHECKR("sin(0.5)", sin(0.5), 0.479425538604203, 1e-15);
    `CHECKX("sin(0)", sin(0.0), 0.0);
    `CHECKR("cos(0.5)", cos(0.5), 0.8775825618903728, 1e-15);
    `CHECKX("cos(0)", cos(0.0), 1.0);
    `CHECKR("tan(0.5) = sin/cos", tan(0.5), 0.5463024898437905, 1e-15);
    `CHECKR("asin(0.5) = pi/6", asin(0.5), 0.5235987755982989, 1e-15);
    `CHECKR("acos(0.5) = pi/3", acos(0.5), 1.0471975511965979, 1e-15);
    `CHECKR("atan(1) = pi/4", atan(1.0), 0.7853981633974483, 1e-15);
    `CHECKR("atan2(1,1) first quadrant", atan2(1.0, 1.0), 0.7853981633974483, 1e-15);
    `CHECKR("atan2(1,-1) second quadrant", atan2(1.0, -1.0), 2.356194490192345, 1e-15);
    `CHECKR("atan2(0,-1) is pi", atan2(0.0, -1.0), 3.141592653589793, 1e-15);
    I(p, n) <+ 0.0;
  end
endmodule
