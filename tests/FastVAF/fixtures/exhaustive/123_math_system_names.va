// §9.14 the IEEE 1364 §17.11 math functions carried into Verilog-AMS: `$ln`,
// `$exp`, `$pow` … are the SAME functions as their bare spellings, not a second
// implementation. Checking them against each other is the whole claim.
//
//! print none
`include "check.vh"
module ex123_math_system_names(p, n);
  inout p, n;
  electrical p, n;
  analog begin
    `CHECKX("$ln == ln", $ln(2.0), ln(2.0));
    `CHECKX("$log10 == log", $log10(1000.0), log(1000.0));
    `CHECKX("$exp == exp", $exp(1.0), exp(1.0));
    `CHECKX("$sqrt == sqrt", $sqrt(2.0), sqrt(2.0));
    `CHECKX("$pow == pow", $pow(2.0, 10.0), pow(2.0, 10.0));
    `CHECKX("$floor == floor", $floor(2.7), floor(2.7));
    `CHECKX("$ceil == ceil", $ceil(2.1), ceil(2.1));
    `CHECKX("$sin == sin", $sin(0.5), sin(0.5));
    `CHECKX("$cos == cos", $cos(0.5), cos(0.5));
    `CHECKX("$tan == tan", $tan(0.5), tan(0.5));
    `CHECKX("$atan2 == atan2", $atan2(1.0, -1.0), atan2(1.0, -1.0));
    `CHECKX("$hypot == hypot", $hypot(3.0, 4.0), hypot(3.0, 4.0));
    `CHECKX("$tanh == tanh", $tanh(0.5), tanh(0.5));
    `CHECKI("$abs == abs", $abs(-3), abs(-3));
    `CHECKI("$min == min", $min(3, 5), min(3, 5));
    `CHECKI("$max == max", $max(3, 5), max(3, 5));
    I(p, n) <+ 0.0;
  end
endmodule
