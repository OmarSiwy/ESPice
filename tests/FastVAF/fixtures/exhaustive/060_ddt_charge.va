// §4.5.3 ddt and §5.6.1.2 the reactive residual. A `ddt` of a charge is NOT
// evaluated as a finite difference by the device: FastVAF splits it out into
// `q()`, and the host differentiates that. So the observable claim is the
// CHARGE and the capacitance matrix dq/dV, which is what the transcript shows —
// and the resistive residual must be identically zero.
//
//! param c = 2p
//! bias V(n) = 0
//! sweep V(p) = 0, 1
`include "check.vh"
module ex060_ddt_charge(p, n);
  inout p, n;
  electrical p, n;
  parameter real c = 1p;
  analog begin
    `CHECK("charge at this bias", c * V(p, n), 2e-12 * V(p, n), 1e-30);
    I(p, n) <+ ddt(c * V(p, n));
  end
endmodule
