// §4.5.10 `last_crossing(expr, direction)` — the DIRECTION argument is not
// decoration. +1 means "the last time expr crossed zero going up", and a
// falling crossing must not answer it. The kernel used to test `(prev < 0) !=
// (in < 0)`, which fires on any sign change, so a rising-only query reported a
// falling edge.
//
// V(in) starts NEGATIVE, so the very first accepted step is a falling crossing
// away from the operator's zero-initialised history — under the old kernel that
// alone set `t_last = 0`, which is what points 1 and 2 below pin. The genuine
// rising crossing happens midway between t = 1n and t = 2n, so the reported
// time is 1n + 0.5*1n = 1.5n, and it only becomes visible at t = 3n (§4.5.2:
// the history advances on the ACCEPTED step, not during the solve).
//
//! bias V(n) = 0
//! wave V(in) = -1, -1, 1, 1
//! time 0, 1n, 2n, 3n
//! analysis tran
//! print none
`include "check.vh"
module ex069_last_crossing_direction(in, n);
  inout in, n;
  electrical in, n;
  analog begin
    `CHECKR("+1 ignores the falling crossing and reports the rising one",
            last_crossing(V(in, n), 1), ($abstime < 2.5n) ? -1.0 : 1.5n, 1e-12);
    I(in, n) <+ 0.0;
  end
endmodule
