// §5.6 the four controlled sources, each as its own branch. A transconductance
// puts its derivative in an OFF-DIAGONAL Jacobian entry — the control node's
// column, not the output branch's — which is the part a hand-written stamp
// most often gets backwards.
//
//! param gm = 2m, rm = 50
//! bias V(cp) = 0.5, V(cn) = 0
//! sweep V(op) = 0, 1
//! bias V(on) = 0
`include "check.vh"
module ex083_controlled(op, on, cp, cn);
  inout op, on, cp, cn;
  electrical op, on, cp, cn;
  parameter real gm = 1m;
  parameter real rm = 1.0;
  analog begin
    `CHECK("control voltage", V(cp, cn), 0.5, 1e-18);
    `CHECK("vccs output current", gm * V(cp, cn), 1e-3, 1e-18);
    I(op, on) <+ gm * V(cp, cn);
    // The control branch draws a small conductive current so the control nodes
    // are not floating; without it the matrix row for `cp` would be empty.
    I(cp, cn) <+ V(cp, cn) * 1e-6;
  end
endmodule
