// §4.3.1 floor/ceil/abs/min/max. These are EXACT for the arguments below — a
// tolerance would hide a wrong rounding direction, which is the only way these
// go wrong.
//
//! print none
`include "check.vh"
module ex041_rounding_selection(p, n);
  inout p, n;
  electrical p, n;
  analog begin
    `CHECKX("floor positive", floor(2.7), 2.0);
    `CHECKX("floor negative rounds down", floor(-2.1), -3.0);
    `CHECKX("floor of an integer value", floor(3.0), 3.0);
    `CHECKX("ceil positive", ceil(2.1), 3.0);
    `CHECKX("ceil negative rounds up", ceil(-2.7), -2.0);
    `CHECKX("abs positive", abs(2.5), 2.5);
    `CHECKX("abs negative", abs(-2.5), 2.5);
    `CHECKX("abs zero", abs(0.0), 0.0);
    `CHECKX("min", min(2.5, -1.0), -1.0);
    `CHECKX("max", max(2.5, -1.0), 2.5);
    `CHECKX("min of equals", min(2.5, 2.5), 2.5);
    I(p, n) <+ 0.0;
  end
endmodule
