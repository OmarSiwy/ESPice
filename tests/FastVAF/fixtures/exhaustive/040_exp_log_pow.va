// §4.3.1 exponential family. The wants are CPython's libm at double precision,
// derived independently of FastVAF; the tolerance is 1 ulp-ish (1e-15 relative)
// because the LRM does not mandate a correctly-rounded libm.
//
//! print none
`include "check.vh"
module ex040_exp_log_pow(p, n);
  inout p, n;
  electrical p, n;
  analog begin
    `CHECKR("exp(1)", exp(1.0), 2.718281828459045, 1e-15);
    `CHECKX("exp(0)", exp(0.0), 1.0);
    `CHECKR("ln(2)", ln(2.0), 0.6931471805599453, 1e-15);
    `CHECKX("ln(1)", ln(1.0), 0.0);
    // §4.3.1: log() is base 10, NOT the natural log. The classic wrong answer.
    `CHECKR("log(1000) is base 10", log(1000.0), 3.0, 1e-15);
    `CHECKR("sqrt(2)", sqrt(2.0), 1.4142135623730951, 1e-15);
    `CHECKX("sqrt(4)", sqrt(4.0), 2.0);
    `CHECKR("pow integer exponent", pow(2.0, 10.0), 1024.0, 1e-15);
    `CHECKR("pow fractional exponent", pow(2.0, 0.5), 1.4142135623730951, 1e-15);
    `CHECKX("pow zero exponent", pow(7.0, 0.0), 1.0);
    `CHECKR("hypot(3,4)", hypot(3.0, 4.0), 5.0, 1e-15);
    I(p, n) <+ 0.0;
  end
endmodule
