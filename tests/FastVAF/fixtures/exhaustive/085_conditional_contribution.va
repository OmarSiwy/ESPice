// §5.8 a contribution under an `if`. §5.6.1.3 makes `<+` an accumulation into a
// place, so a conditional contribution is "the accumulator's value at the end of
// the analog block" — a phi, not a second device. The sweep crosses the
// threshold so the transcript shows both arms and the slope discontinuity.
//
//! param vth = 0.5, g_on = 1m, g_off = 1n
//! bias V(n) = 0
//! sweep V(p) = 0, 0.4, 0.6, 1
`include "check.vh"
module ex085_conditional(p, n);
  inout p, n;
  electrical p, n;
  parameter real vth = 0.5;
  parameter real g_on = 1m;
  parameter real g_off = 1n;
  analog begin
    // The verdict is an operand, not a branch: see check.vh for why a `$strobe`
    // under an `if` is dropped with W0851.
    `CHECKI("above threshold?", V(p, n) > vth, (V(p, n) > vth));
    if (V(p, n) > vth)
      I(p, n) <+ g_on * V(p, n);
    else
      I(p, n) <+ g_off * V(p, n);
  end
endmodule
