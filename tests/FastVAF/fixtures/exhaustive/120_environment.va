// §9.10/§9.15 the environment functions: what the model can ask the simulator
// about the operating conditions. `$vt` is the thermal voltage that every
// junction model divides by, so its exact value matters more than most.
//
//! temp 350
//! print none
`include "check.vh"
module ex120_environment(p, n);
  inout p, n;
  electrical p, n;
  analog begin
    `CHECK("$temperature follows the directive", $temperature, 350.0, 0.0);
    // §9.10: $vt = k*T/q with k/q = 8.617333262145179e-5 V/K.
    `CHECKR("$vt with no argument uses $temperature", $vt,
            350.0 * 8.617333262145179e-5, 1e-15);
    `CHECKR("$vt(T) uses its argument", $vt(300.0),
            300.0 * 8.617333262145179e-5, 1e-15);
    `CHECKX("$abstime at the DC point", $abstime, 0.0);
    // §9.15 $simparam defaults, which a simulator-free device answers itself.
    `CHECKX("$simparam gmin default", $simparam("gmin"), 1e-12);
    `CHECKX("$simparam tnom default", $simparam("tnom"), 300.15);
    `CHECKX("$simparam scale default", $simparam("scale"), 1.0);
    `CHECKX("$simparam with an explicit default", $simparam("nosuch", 4.5), 4.5);
    I(p, n) <+ 0.0;
  end
endmodule
