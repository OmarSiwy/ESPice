// The `//!` driver directives themselves (src/tb.zig): every one of them has to
// be observable in the transcript, or a fixture could silently not be testing
// what its header says.
//
//! param g = 3m, off = 0.5
//! bias V(n) = 0.25
//! sweep V(p) = 0, 1
//! temp 350
//! analysis tran
`include "check.vh"
module ex012_directives(p, n);
  inout p, n;
  electrical p, n;
  parameter real g = 1m;
  parameter real off = 0.0;
  analog begin
    `CHECK("param g overridden", g, 3e-3, 0.0);
    `CHECK("param off overridden", off, 0.5, 0.0);
    `CHECK("temp directive reaches $temperature", $temperature, 350.0, 0.0);
    `CHECKI("analysis(\"tran\") is true", analysis("tran"), 1);
    `CHECKI("analysis(\"dc\") is false", analysis("dc"), 0);
    $strobe("bias+sweep: V(p)=%g V(n)=%g V(p,n)=%g", V(p), V(n), V(p, n));
    I(p, n) <+ g * (V(p, n) - off);
  end
endmodule
