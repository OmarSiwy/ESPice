// §5.6 a POTENTIAL contribution. Its topology is not the resistor's: the branch
// current becomes an unknown of its own (`flow(p,n)`, appended after the nodes),
// and the residual row is `V(p,n) - value`. The transcript shows the extra
// unknown and the off-diagonal +/-1 stamps that carry it into KCL.
//
//! param e = 1.5
//! bias V(n) = 0
//! sweep V(p) = 0, 1.5
`include "check.vh"
module ex082_voltage_source(p, n);
  inout p, n;
  electrical p, n;
  parameter real e = 1.0;
  analog begin
    `CHECK("source value", e, 1.5, 0.0);
    V(p, n) <+ e;
  end
endmodule
