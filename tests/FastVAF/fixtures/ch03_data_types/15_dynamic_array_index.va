module ch03_dynamic_array_index(p, n);
    inout p, n;
    electrical p, n;
    real values[0:2];
    integer index;

    analog begin
        values[0] = 1.0;
        values[1] = 2.0;
        values[2] = 3.0;
        index = V(p, n) > 0.0 ? 1 : 2;
        I(p, n) <+ values[index];
    end
endmodule
