nature ch03_potential;
    units = "V";
    access = V;
    abstol = 1u;
endnature

nature ch03_flow;
    units = "A";
    access = I;
    abstol = 1p;
endnature

discipline ch03_conservative;
    domain continuous;
    potential ch03_potential;
    flow ch03_flow;
enddiscipline

discipline ch03_potential_only;
    potential ch03_potential;
enddiscipline

discipline ch03_flow_only;
    flow ch03_flow;
enddiscipline

module ch03_discipline_declarations(p, n);
    inout p, n;
    electrical p, n;
    analog I(p, n) <+ V(p, n);
endmodule
