module ch03_named_branches(p, n);
    inout p, n;
    electrical p, n;
    branch (p, n) differential_branch;
    branch (p) ground_branch;

    analog begin
        I(differential_branch) <+ V(differential_branch) / 100.0;
        I(ground_branch) <+ V(ground_branch) / 200.0;
    end
endmodule
