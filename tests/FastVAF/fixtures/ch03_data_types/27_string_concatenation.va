module ch3_string_concat(p); inout p; electrical p; string a="hello",b="world",c; analog begin c={a," ",b}; I(p)<+0.0*V(p); end endmodule
