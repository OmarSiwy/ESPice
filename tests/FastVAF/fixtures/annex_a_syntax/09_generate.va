module annex_a_generate(p, n);
    inout p, n;
    electrical p, n;
    genvar index;

    generate
        for (index = 0; index < 2; index = index + 1)
            I(p, n) <+ index * V(p, n);
    endgenerate
endmodule
