module ch09_atomic_fwrite(p, n);
  inout p, n; electrical p, n;
  integer fd;
  analog begin
    fd = $fopen("fixture.log", "a");
    $fwrite(fd, "value=%g", V(p,n));
    I(p,n) <+ V(p,n);
  end
endmodule
