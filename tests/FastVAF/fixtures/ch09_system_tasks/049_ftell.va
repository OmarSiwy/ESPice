module ch09_atomic_ftell(p, n);
  inout p, n; electrical p, n;
  integer fd, position;
  analog begin
    fd = $fopen("fixture.dat", "r");
    position = $ftell(fd);
    I(p,n) <+ V(p,n) + position;
  end
endmodule
