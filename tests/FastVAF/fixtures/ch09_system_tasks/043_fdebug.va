module ch09_atomic_fdebug(p, n);
  inout p, n; electrical p, n;
  integer fd;
  analog begin
    fd = $fopen("fixture.log", "a");
    $fdebug(fd, "value=%g", V(p,n));
    I(p,n) <+ V(p,n);
  end
endmodule
