module ch09_atomic_fgets(p, n);
  inout p, n; electrical p, n;
  integer fd, code; string text;
  analog begin
    fd = $fopen("fixture.dat", "r");
    code = $fgets(text, fd);
    I(p,n) <+ V(p,n) + code;
  end
endmodule
