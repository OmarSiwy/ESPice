module ch09_atomic_xposition(p, n);
  inout p, n; electrical p, n;
  analog I(p,n) <+ V(p,n) + $xposition;
endmodule
