// NONCONFORMING ACCEPTANCE SNAPSHOT: $driver_next_state is valid only in the digital context of a connectmodule.
module ch09_atomic_driver_next_state(p, n);
  inout p, n; electrical p, n;
  analog I(p,n) <+ V(p,n) + $driver_next_state(p,0);
endmodule
