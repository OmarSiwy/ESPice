module ch09_atomic_port_connected(p, n);
  inout p, n; electrical p, n;
  analog begin
    if ($port_connected(p)) I(p,n) <+ V(p,n);
    else I(p,n) <+ 0.0;
  end
endmodule
