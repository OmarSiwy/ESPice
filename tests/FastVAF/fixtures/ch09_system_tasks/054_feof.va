module ch09_atomic_feof(p, n);
  inout p, n; electrical p, n;
  integer fd, code;
  analog begin
    fd = $fopen("fixture.dat", "r");
    code = $feof(fd);
    I(p,n) <+ V(p,n) + code;
  end
endmodule
