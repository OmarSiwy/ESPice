module ch09_atomic_floor(p, n);
  inout p, n; electrical p, n;
  analog I(p,n) <+ V(p,n) + $floor(1.9);
endmodule
