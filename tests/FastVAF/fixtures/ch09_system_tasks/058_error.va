module ch09_atomic_error(p, n);
  inout p, n; electrical p, n;
  analog begin
    if (V(p,n) > 1.0) $error("voltage=%g", V(p,n));
    I(p,n) <+ V(p,n);
  end
endmodule
