module ch09_severity_tasks(p, n);
  inout p, n; electrical p, n;
  analog begin
    if (V(p,n) > 1.0) $info("info %g", V(p,n));
    if (V(p,n) > 2.0) $warning("warning %g", V(p,n));
    if (V(p,n) > 3.0) $error("error %g", V(p,n));
    if (V(p,n) > 4.0) $fatal(1, "fatal %g", V(p,n));
    I(p,n) <+ V(p,n);
  end
endmodule
