module ch09_atomic_sin(p, n);
  inout p, n; electrical p, n;
  analog I(p,n) <+ V(p,n) + $sin(V(p,n));
endmodule
