module ch09_atomic_analog_node_alias(p, n);
  inout p, n; electrical p, n;
  electrical local_node; integer status;
  analog initial begin
    status = $analog_node_alias(local_node, "$root.top.n");
  end
  analog I(p,n) <+ V(local_node) + status * 0.0;
endmodule
