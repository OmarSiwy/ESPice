module ch09_atomic_clog2(p, n);
  inout p, n; electrical p, n;
  analog I(p,n) <+ V(p,n) + $clog2(9);
endmodule
