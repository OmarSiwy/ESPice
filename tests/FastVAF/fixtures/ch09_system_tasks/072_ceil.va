module ch09_atomic_ceil(p, n);
  inout p, n; electrical p, n;
  analog I(p,n) <+ V(p,n) + $ceil(1.1);
endmodule
