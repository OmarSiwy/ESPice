module ch09_atomic_max(p, n);
  inout p, n; electrical p, n;
  analog I(p,n) <+ V(p,n) + $max(V(p,n), 0.0);
endmodule
