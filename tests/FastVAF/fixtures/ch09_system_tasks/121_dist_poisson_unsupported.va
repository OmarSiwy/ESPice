// EXPECT: error
module ch09_dist_poisson_unsupported(p, n);
  inout p, n; electrical p, n;
  integer seed;
  analog I(p,n) <+ $dist_poisson(seed, 3);
endmodule
