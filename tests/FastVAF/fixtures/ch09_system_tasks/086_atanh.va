module ch09_atomic_atanh(p, n);
  inout p, n; electrical p, n;
  analog I(p,n) <+ V(p,n) + $atanh(0.5 * tanh(V(p,n)));
endmodule
