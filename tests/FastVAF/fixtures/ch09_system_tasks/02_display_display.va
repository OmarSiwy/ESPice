module ch09_display_display(p, n);
  inout p, n; electrical p, n;
  analog begin
    $display("accepted value %e", V(p,n));
    I(p,n) <+ V(p,n);
  end
endmodule
