module ch09_atomic_angle(p, n);
  inout p, n; electrical p, n;
  analog I(p,n) <+ V(p,n) + $angle;
endmodule
