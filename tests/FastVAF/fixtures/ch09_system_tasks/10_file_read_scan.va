module ch09_file_read_scan(p, n);
  inout p, n; electrical p, n;
  integer fd, code, value;
  string line;
  analog begin
    fd = $fopen("fixture.dat", "r");
    code = $fgets(line, fd);
    code = $fscanf(fd, "%d", value);
    code = $sscanf("42", "%d", value);
    I(p,n) <+ value + 0.0*V(p,n);
  end
endmodule
