module ch09_abstime(p, n);
  inout p, n; electrical p, n;
  analog I(p,n) <+ $abstime + 0.0*V(p,n);
endmodule
