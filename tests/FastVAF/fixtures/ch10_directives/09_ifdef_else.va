`define ENABLE_GAIN
module ch10_ifdef_else(p, n);
  inout p, n; electrical p, n;
  analog begin
`ifdef ENABLE_GAIN
    I(p,n) <+ 4.0*V(p,n);
`else
    I(p,n) <+ V(p,n);
`endif
  end
endmodule
