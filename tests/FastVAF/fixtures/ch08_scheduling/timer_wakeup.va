module ch8_timer_wakeup(p);
  inout p; electrical p; real state;
  analog begin
    @(timer(1n, 2n, 1p)) state = 1.0 - state;
    V(p) <+ transition(state, 0.0, 1p);
  end
endmodule
