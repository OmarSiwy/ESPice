* Noise suppressed by ideal voltage drive
* Expected results: clamped_output.expected.json
Vin out 0 AC 1 SIN(0 1 1k)
R1 out 0 1k
.pnoise v(out) Vin dec 3 10 10k 1k 3
.end
