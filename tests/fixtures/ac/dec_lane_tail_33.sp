* 33 frequency lanes with DEC sweep
* Expected results: dec_lane_tail_33.expected.json
Vin in 0 AC 1
R1 in out 1k
C1 out 0 1u
.ac dec 32 1k 10k
.end
