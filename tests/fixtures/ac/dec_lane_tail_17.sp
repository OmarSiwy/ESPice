* 17 frequency lanes with DEC sweep
* Expected results: dec_lane_tail_17.expected.json
Vin in 0 AC 1
R1 in out 1k
C1 out 0 1u
.ac dec 16 1k 10k
.end
