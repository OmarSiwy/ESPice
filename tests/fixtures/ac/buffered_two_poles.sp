* buffered two poles
* Expected results: buffered_two_poles.expected.json
Vin in 0 AC 1
R1 in a 1k
C1 a 0 1u
Ebuf b 0 a 0 1
R2 b out 1k
C2 out 0 1u
.ac dec 4 10 10k
.end
