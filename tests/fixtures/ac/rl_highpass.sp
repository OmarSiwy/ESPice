* rl highpass
* Expected results: rl_highpass.expected.json
Vin in 0 AC 1
R1 in out 1k
L1 out 0 1
.ac dec 4 10 10k
.end
