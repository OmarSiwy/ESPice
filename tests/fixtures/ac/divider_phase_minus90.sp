* AC magnitude and phase -90 degrees
* Expected results: divider_phase_minus90.expected.json
Vin in 0 DC 7 AC 2 -90
R1 in out 1000
R2 out 0 3000
.ac dec 4 10 10k
.end
