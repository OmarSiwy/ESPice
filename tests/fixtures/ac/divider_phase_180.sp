* AC magnitude and phase 180 degrees
* Expected results: divider_phase_180.expected.json
Vin in 0 DC 7 AC 2 180
R1 in out 1000
R2 out 0 3000
.ac dec 4 10 10k
.end
