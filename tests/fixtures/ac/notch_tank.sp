* notch tank
* Expected results: notch_tank.expected.json
Vin in 0 AC 1
R1 in out 100
L1 out a 1m
C1 a 0 1u
.ac dec 4 10 10k
.end
