* rc highpass
* Expected results: rc_highpass.expected.json
Vin in 0 AC 1
C1 in out 1u
R1 out 0 1k
.ac dec 4 10 10k
.end
