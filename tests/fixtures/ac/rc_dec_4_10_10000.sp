* RC lowpass on dec frequency grid
* Expected results: rc_dec_4_10_10000.expected.json
Vin in 0 DC 0 AC 1
R1 in out 1k
C1 out 0 1u
.ac dec 4 10 10000
.end
