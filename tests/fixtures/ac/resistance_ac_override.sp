* AC-only resistance differs from DC value
* Expected results: resistance_ac_override.expected.json
Vin in 0 DC 1 AC 1
R1 in out 1k ac=2k
R2 out 0 1k
.ac dec 3 10 10k
.end
