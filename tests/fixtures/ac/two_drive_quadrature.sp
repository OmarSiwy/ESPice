* two drive quadrature
* Expected results: two_drive_quadrature.expected.json
V1 a 0 AC 1 0
V2 b 0 AC 1 90
R1 a out 1k
R2 b out 1k
R3 out 0 1k
.ac dec 4 10 10k
.end
