* Resonant amplification and conditioning near pole frequency
* KNOWN GAP: non-DEC frequency sweeps are not yet supported by the shared analysis dispatcher.
* This correctness test should currently fail; implement support to match the expected output.
* Expected results: rlc_near_resonance_10.expected.json
Vin in 0 AC 1
R1 in a 632.4555320336759
L1 a out 1m
C1 out 0 1u
.ac lin 3 4982.591998344216 5083.25042255319
.end
