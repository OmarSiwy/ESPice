* vccs transimpedance
* Expected results: vccs_transimpedance.expected.json
Vin in 0 AC 1
G1 out 0 in 0 .002
R1 out 0 1k
C1 out 0 1u
.ac dec 4 10 10k
.end
