* two drive cancellation
* Expected results: two_drive_cancellation.expected.json
V1 a 0 AC 1 0
V2 b 0 AC 1 180
R1 a out 1k
R2 b out 1k
.ac dec 4 10 10k
.end
