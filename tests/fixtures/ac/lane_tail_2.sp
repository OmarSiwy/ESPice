* 2 independent frequency points, vector batch tails
* Expected results: lane_tail_2.expected.json
Vin in 0 AC 1
R1 in out 1k
C1 out 0 1u
.ac lin 2 10 10k
.end
