* current source rc
* Expected results: current_source_rc.expected.json
Iin 0 out AC 1m
R1 out 0 1k
C1 out 0 1u
.ac dec 4 10 10k
.end
