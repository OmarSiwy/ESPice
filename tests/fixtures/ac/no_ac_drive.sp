* no ac drive
* Expected results: no_ac_drive.expected.json
Vin in 0 3
R1 in out 1000
R2 out 0 3000
.ac dec 4 10 10k
.end
