* rlc lowpass
* Expected results: rlc_lowpass.expected.json
Vin in 0 AC 1
R1 in a 10
L1 a out 1m
C1 out 0 1u
.ac dec 4 10 10k
.end
