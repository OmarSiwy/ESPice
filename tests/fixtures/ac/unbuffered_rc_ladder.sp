* unbuffered rc ladder
* Expected results: unbuffered_rc_ladder.expected.json
Vin in 0 AC 1
R1 in a 1k
C1 a 0 1u
R2 a out 1k
C2 out 0 1u
.ac dec 4 10 10k
.end
