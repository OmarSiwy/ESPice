* second source drive
* Expected results: second_source_drive.expected.json
Vbias bias 0 5
Vin in 0 AC 1
R1 in out 1k
R2 out 0 3k
Rb bias 0 1k
.ac dec 4 10 10k
.end
