* floating ac source
* Expected results: floating_ac_source.expected.json
Vin a b AC 1
R1 a 0 1k
R2 b out 1k
R3 out 0 1k
.ac dec 4 10 10k
.end
