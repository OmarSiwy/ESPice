* Resonant amplification and conditioning near pole frequency
* Expected results: rlc_near_resonance_0p001.expected.json
Vin in 0 AC 1
R1 in a 0.0632455532033676
L1 a out 1m
C1 out 0 1u
.ac lin 3 4982.591998344216 5083.25042255319
.end
