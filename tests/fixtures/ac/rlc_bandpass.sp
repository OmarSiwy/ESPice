* rlc bandpass
* Expected results: rlc_bandpass.expected.json
Vin in 0 AC 1
L1 in a 1m
C1 a out 1u
R1 out 0 10
.ac dec 4 10 10k
.end
