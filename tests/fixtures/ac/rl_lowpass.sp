* rl lowpass
* Expected results: rl_lowpass.expected.json
Vin in 0 AC 1
L1 in out 1
R1 out 0 1k
.ac dec 4 10 10k
.end
