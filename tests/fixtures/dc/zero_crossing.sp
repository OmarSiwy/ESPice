* DC zero_crossing
* Expected results: zero_crossing.expected.json
Vin in 0 0
R1 in out 1000
R2 out 0 3000
.dc Vin -0.2 0.2 0.1
.end
