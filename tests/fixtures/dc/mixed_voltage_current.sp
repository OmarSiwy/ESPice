* Current sweep in a circuit that also contains a voltage source
* Expected results: mixed_voltage_current.expected.json
Vbias bias 0 1
Iin 0 out 0
R1 out bias 1k
.dc Iin -1m 1m .5m
.end
