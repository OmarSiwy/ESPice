* Select the second voltage source by name
* Expected results: second_voltage_source.expected.json
Vbias bias 0 3
Vin in 0 0
R1 in out 1k
R2 out bias 1k
.dc Vin -1 1 .5
.end
