* DC ascending
* Expected results: ascending.expected.json
Vin in 0 0
R1 in out 1000
R2 out 0 3000
.dc Vin -2 2 0.5
.end
