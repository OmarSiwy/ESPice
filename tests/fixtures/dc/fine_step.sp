* DC fine_step
* Expected results: fine_step.expected.json
Vin in 0 0
R1 in out 1000
R2 out 0 3000
.dc Vin 0 0.01 0.001
.end
