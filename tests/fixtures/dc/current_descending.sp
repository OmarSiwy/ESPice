* Sweep an independent current source
* Expected results: current_descending.expected.json
Iin 0 out 0
R1 out 0 1k
.dc Iin 0.002 -0.002 -0.001
.end
