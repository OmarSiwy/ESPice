* DC nondivisible_stop
* Expected results: nondivisible_stop.expected.json
Vin in 0 0
R1 in out 1000
R2 out 0 3000
.dc Vin 0 1 0.3
.end
