* DC single_point
* Expected results: single_point.expected.json
Vin in 0 0
R1 in out 1000
R2 out 0 3000
.dc Vin 1 1 0.25
.end
