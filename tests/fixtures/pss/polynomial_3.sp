* Nonlinear memoryless periodic orbit
* Expected results: polynomial_3.expected.json
Vin in 0 SIN(0 1 1k)
Bout out 0 V=V(in)^3
Rload out 0 1k
.pss 1k 256
.end
