* Periodic RC orbit
* Expected results: rc_fast.expected.json
Vin in 0 SIN(0 1 1k)
R1 in out 1000
C1 out 0 1e-09
.pss 1k 256
.end
