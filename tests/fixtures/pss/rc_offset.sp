* Periodic RC orbit
* Expected results: rc_offset.expected.json
Vin in 0 SIN(3 2 1k)
R1 in out 1000
C1 out 0 1e-06
.pss 1k 256
.end
