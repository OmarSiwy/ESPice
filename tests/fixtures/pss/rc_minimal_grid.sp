* Periodic RC orbit
* Expected results: rc_minimal_grid.expected.json
Vin in 0 SIN(0 1 1k)
R1 in out 1000
C1 out 0 1e-06
.pss 1k 32
.end
