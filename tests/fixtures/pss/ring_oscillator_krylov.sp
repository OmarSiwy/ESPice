* Autonomous shooting PSS on the Krylov path: a 17-stage ring, 51 unknowns
* Expected results: ring_oscillator_krylov.expected.json
* pss.zig switches from the dense finite-difference Jacobian to matrix-free
* GMRES at 50 unknowns; each stage is a node pair plus a B-source branch.
R1 x1 c1 1k
C1 c1 0 1n
B1 x1 0 V=-tanh(3*V(c17))
R2 x2 c2 1k
C2 c2 0 1n
B2 x2 0 V=-tanh(3*V(c1))
R3 x3 c3 1k
C3 c3 0 1n
B3 x3 0 V=-tanh(3*V(c2))
R4 x4 c4 1k
C4 c4 0 1n
B4 x4 0 V=-tanh(3*V(c3))
R5 x5 c5 1k
C5 c5 0 1n
B5 x5 0 V=-tanh(3*V(c4))
R6 x6 c6 1k
C6 c6 0 1n
B6 x6 0 V=-tanh(3*V(c5))
R7 x7 c7 1k
C7 c7 0 1n
B7 x7 0 V=-tanh(3*V(c6))
R8 x8 c8 1k
C8 c8 0 1n
B8 x8 0 V=-tanh(3*V(c7))
R9 x9 c9 1k
C9 c9 0 1n
B9 x9 0 V=-tanh(3*V(c8))
R10 x10 c10 1k
C10 c10 0 1n
B10 x10 0 V=-tanh(3*V(c9))
R11 x11 c11 1k
C11 c11 0 1n
B11 x11 0 V=-tanh(3*V(c10))
R12 x12 c12 1k
C12 c12 0 1n
B12 x12 0 V=-tanh(3*V(c11))
R13 x13 c13 1k
C13 c13 0 1n
B13 x13 0 V=-tanh(3*V(c12))
R14 x14 c14 1k
C14 c14 0 1n
B14 x14 0 V=-tanh(3*V(c13))
R15 x15 c15 1k
C15 c15 0 1n
B15 x15 0 V=-tanh(3*V(c14))
R16 x16 c16 1k
C16 c16 0 1n
B16 x16 0 V=-tanh(3*V(c15))
R17 x17 c17 1k
C17 c17 0 1n
B17 x17 0 V=-tanh(3*V(c16))
.pss v(c1) 38k 512
.end
