* DC solution is a periodic fixed point for every period
* Expected results: dc_is_periodic.expected.json
Vin in 0 4
R1 in out 1000
R2 out 0 3000
.pss 1k
.end
