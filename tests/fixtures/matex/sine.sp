* Matrix-exponential propagation of a driven RC
* Expected results: sine.expected.json
Vin in 0 SIN(0 1 1k)
R1 in out 1k
C1 out 0 1u
.matex 1u 5m
.end
