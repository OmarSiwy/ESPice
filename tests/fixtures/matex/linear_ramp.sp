* Matrix-exponential propagation of a driven RC
* Expected results: linear_ramp.expected.json
Vin in 0 PWL(0 0 5m 5)
R1 in out 1k
C1 out 0 1u
.matex 1u 5m
.end
