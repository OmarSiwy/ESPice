* Matrix-exponential propagation of a driven RC
* Expected results: dc.expected.json
Vin in 0 DC 2
R1 in out 1k
C1 out 0 1u
.matex 1u 5m
.end
