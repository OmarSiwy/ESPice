* No dynamic states: MATEX reduces to algebraic solve
* Expected results: purely_algebraic.expected.json
Vin in 0 PWL(0 0 1m 1 2m 0)
R1 in out 1000
R2 out 0 3000
.matex 1u 2m
.end
