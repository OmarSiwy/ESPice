* One-port resistive reflection
* Expected results: one_port_100.expected.json
Vp out 0 DC 0 AC 1 portnum 1 z0 50
R1 out 0 100
.sp dec 3 1k 1meg
.end
