* Two-port series resistance and unequal reference impedances
* Expected results: series_25_z_25_100.expected.json
Vp1 a 0 0 AC 1 portnum 1 z0 25
R1 a b 25
Vp2 b 0 0 portnum 2 z0 100
.sp dec 3 1k 1meg
.end
