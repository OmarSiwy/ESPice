* Linear SP grid and matched reflection
* Expected results: linear_grid_3.expected.json
Vp out 0 0 AC 1 portnum 1 z0 50
R1 out 0 50
.sp lin 3 1k 1meg
.end
