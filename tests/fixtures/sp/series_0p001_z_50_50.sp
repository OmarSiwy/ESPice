* Two-port series resistance and unequal reference impedances
* Expected results: series_0p001_z_50_50.expected.json
Vp1 a 0 0 AC 1 portnum 1 z0 50
R1 a b 0.001
Vp2 b 0 0 portnum 2 z0 50
.sp dec 3 1k 1meg
.end
