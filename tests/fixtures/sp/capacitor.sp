* Reactive one-port magnitude and phase
* Expected results: capacitor.expected.json
Vp out 0 DC 0 AC 1 portnum 1 z0 50
C1 out 0 1n
.sp dec 3 1k 1meg
.end
