* 600-resistor series divider chain (600+ nodes): scaling DC sweep.
* Expected results: scaling_divider_chain.expected.json
* Origin: benchmark/fixtures/scaling/divider_chain/circuit.sp
V1 n0 0 DC 600
R1 n0 n1 1k
R2 n1 n2 1k
R3 n2 n3 1k
R4 n3 n4 1k
R5 n4 n5 1k
R6 n5 n6 1k
R7 n6 n7 1k
R8 n7 n8 1k
R9 n8 n9 1k
R10 n9 n10 1k
R11 n10 n11 1k
R12 n11 n12 1k
R13 n12 n13 1k
R14 n13 n14 1k
R15 n14 n15 1k
R16 n15 n16 1k
R17 n16 n17 1k
R18 n17 n18 1k
R19 n18 n19 1k
R20 n19 n20 1k
R21 n20 n21 1k
R22 n21 n22 1k
R23 n22 n23 1k
R24 n23 n24 1k
R25 n24 n25 1k
R26 n25 n26 1k
R27 n26 n27 1k
R28 n27 n28 1k
R29 n28 n29 1k
R30 n29 n30 1k
R31 n30 n31 1k
R32 n31 n32 1k
R33 n32 n33 1k
R34 n33 n34 1k
R35 n34 n35 1k
R36 n35 n36 1k
R37 n36 n37 1k
R38 n37 n38 1k
R39 n38 n39 1k
R40 n39 n40 1k
R41 n40 n41 1k
R42 n41 n42 1k
R43 n42 n43 1k
R44 n43 n44 1k
R45 n44 n45 1k
R46 n45 n46 1k
R47 n46 n47 1k
R48 n47 n48 1k
R49 n48 n49 1k
R50 n49 n50 1k
R51 n50 n51 1k
R52 n51 n52 1k
R53 n52 n53 1k
R54 n53 n54 1k
R55 n54 n55 1k
R56 n55 n56 1k
R57 n56 n57 1k
R58 n57 n58 1k
R59 n58 n59 1k
R60 n59 n60 1k
R61 n60 n61 1k
R62 n61 n62 1k
R63 n62 n63 1k
R64 n63 n64 1k
R65 n64 n65 1k
R66 n65 n66 1k
R67 n66 n67 1k
R68 n67 n68 1k
R69 n68 n69 1k
R70 n69 n70 1k
R71 n70 n71 1k
R72 n71 n72 1k
R73 n72 n73 1k
R74 n73 n74 1k
R75 n74 n75 1k
R76 n75 n76 1k
R77 n76 n77 1k
R78 n77 n78 1k
R79 n78 n79 1k
R80 n79 n80 1k
R81 n80 n81 1k
R82 n81 n82 1k
R83 n82 n83 1k
R84 n83 n84 1k
R85 n84 n85 1k
R86 n85 n86 1k
R87 n86 n87 1k
R88 n87 n88 1k
R89 n88 n89 1k
R90 n89 n90 1k
R91 n90 n91 1k
R92 n91 n92 1k
R93 n92 n93 1k
R94 n93 n94 1k
R95 n94 n95 1k
R96 n95 n96 1k
R97 n96 n97 1k
R98 n97 n98 1k
R99 n98 n99 1k
R100 n99 n100 1k
R101 n100 n101 1k
R102 n101 n102 1k
R103 n102 n103 1k
R104 n103 n104 1k
R105 n104 n105 1k
R106 n105 n106 1k
R107 n106 n107 1k
R108 n107 n108 1k
R109 n108 n109 1k
R110 n109 n110 1k
R111 n110 n111 1k
R112 n111 n112 1k
R113 n112 n113 1k
R114 n113 n114 1k
R115 n114 n115 1k
R116 n115 n116 1k
R117 n116 n117 1k
R118 n117 n118 1k
R119 n118 n119 1k
R120 n119 n120 1k
R121 n120 n121 1k
R122 n121 n122 1k
R123 n122 n123 1k
R124 n123 n124 1k
R125 n124 n125 1k
R126 n125 n126 1k
R127 n126 n127 1k
R128 n127 n128 1k
R129 n128 n129 1k
R130 n129 n130 1k
R131 n130 n131 1k
R132 n131 n132 1k
R133 n132 n133 1k
R134 n133 n134 1k
R135 n134 n135 1k
R136 n135 n136 1k
R137 n136 n137 1k
R138 n137 n138 1k
R139 n138 n139 1k
R140 n139 n140 1k
R141 n140 n141 1k
R142 n141 n142 1k
R143 n142 n143 1k
R144 n143 n144 1k
R145 n144 n145 1k
R146 n145 n146 1k
R147 n146 n147 1k
R148 n147 n148 1k
R149 n148 n149 1k
R150 n149 n150 1k
R151 n150 n151 1k
R152 n151 n152 1k
R153 n152 n153 1k
R154 n153 n154 1k
R155 n154 n155 1k
R156 n155 n156 1k
R157 n156 n157 1k
R158 n157 n158 1k
R159 n158 n159 1k
R160 n159 n160 1k
R161 n160 n161 1k
R162 n161 n162 1k
R163 n162 n163 1k
R164 n163 n164 1k
R165 n164 n165 1k
R166 n165 n166 1k
R167 n166 n167 1k
R168 n167 n168 1k
R169 n168 n169 1k
R170 n169 n170 1k
R171 n170 n171 1k
R172 n171 n172 1k
R173 n172 n173 1k
R174 n173 n174 1k
R175 n174 n175 1k
R176 n175 n176 1k
R177 n176 n177 1k
R178 n177 n178 1k
R179 n178 n179 1k
R180 n179 n180 1k
R181 n180 n181 1k
R182 n181 n182 1k
R183 n182 n183 1k
R184 n183 n184 1k
R185 n184 n185 1k
R186 n185 n186 1k
R187 n186 n187 1k
R188 n187 n188 1k
R189 n188 n189 1k
R190 n189 n190 1k
R191 n190 n191 1k
R192 n191 n192 1k
R193 n192 n193 1k
R194 n193 n194 1k
R195 n194 n195 1k
R196 n195 n196 1k
R197 n196 n197 1k
R198 n197 n198 1k
R199 n198 n199 1k
R200 n199 n200 1k
R201 n200 n201 1k
R202 n201 n202 1k
R203 n202 n203 1k
R204 n203 n204 1k
R205 n204 n205 1k
R206 n205 n206 1k
R207 n206 n207 1k
R208 n207 n208 1k
R209 n208 n209 1k
R210 n209 n210 1k
R211 n210 n211 1k
R212 n211 n212 1k
R213 n212 n213 1k
R214 n213 n214 1k
R215 n214 n215 1k
R216 n215 n216 1k
R217 n216 n217 1k
R218 n217 n218 1k
R219 n218 n219 1k
R220 n219 n220 1k
R221 n220 n221 1k
R222 n221 n222 1k
R223 n222 n223 1k
R224 n223 n224 1k
R225 n224 n225 1k
R226 n225 n226 1k
R227 n226 n227 1k
R228 n227 n228 1k
R229 n228 n229 1k
R230 n229 n230 1k
R231 n230 n231 1k
R232 n231 n232 1k
R233 n232 n233 1k
R234 n233 n234 1k
R235 n234 n235 1k
R236 n235 n236 1k
R237 n236 n237 1k
R238 n237 n238 1k
R239 n238 n239 1k
R240 n239 n240 1k
R241 n240 n241 1k
R242 n241 n242 1k
R243 n242 n243 1k
R244 n243 n244 1k
R245 n244 n245 1k
R246 n245 n246 1k
R247 n246 n247 1k
R248 n247 n248 1k
R249 n248 n249 1k
R250 n249 n250 1k
R251 n250 n251 1k
R252 n251 n252 1k
R253 n252 n253 1k
R254 n253 n254 1k
R255 n254 n255 1k
R256 n255 n256 1k
R257 n256 n257 1k
R258 n257 n258 1k
R259 n258 n259 1k
R260 n259 n260 1k
R261 n260 n261 1k
R262 n261 n262 1k
R263 n262 n263 1k
R264 n263 n264 1k
R265 n264 n265 1k
R266 n265 n266 1k
R267 n266 n267 1k
R268 n267 n268 1k
R269 n268 n269 1k
R270 n269 n270 1k
R271 n270 n271 1k
R272 n271 n272 1k
R273 n272 n273 1k
R274 n273 n274 1k
R275 n274 n275 1k
R276 n275 n276 1k
R277 n276 n277 1k
R278 n277 n278 1k
R279 n278 n279 1k
R280 n279 n280 1k
R281 n280 n281 1k
R282 n281 n282 1k
R283 n282 n283 1k
R284 n283 n284 1k
R285 n284 n285 1k
R286 n285 n286 1k
R287 n286 n287 1k
R288 n287 n288 1k
R289 n288 n289 1k
R290 n289 n290 1k
R291 n290 n291 1k
R292 n291 n292 1k
R293 n292 n293 1k
R294 n293 n294 1k
R295 n294 n295 1k
R296 n295 n296 1k
R297 n296 n297 1k
R298 n297 n298 1k
R299 n298 n299 1k
R300 n299 n300 1k
R301 n300 n301 1k
R302 n301 n302 1k
R303 n302 n303 1k
R304 n303 n304 1k
R305 n304 n305 1k
R306 n305 n306 1k
R307 n306 n307 1k
R308 n307 n308 1k
R309 n308 n309 1k
R310 n309 n310 1k
R311 n310 n311 1k
R312 n311 n312 1k
R313 n312 n313 1k
R314 n313 n314 1k
R315 n314 n315 1k
R316 n315 n316 1k
R317 n316 n317 1k
R318 n317 n318 1k
R319 n318 n319 1k
R320 n319 n320 1k
R321 n320 n321 1k
R322 n321 n322 1k
R323 n322 n323 1k
R324 n323 n324 1k
R325 n324 n325 1k
R326 n325 n326 1k
R327 n326 n327 1k
R328 n327 n328 1k
R329 n328 n329 1k
R330 n329 n330 1k
R331 n330 n331 1k
R332 n331 n332 1k
R333 n332 n333 1k
R334 n333 n334 1k
R335 n334 n335 1k
R336 n335 n336 1k
R337 n336 n337 1k
R338 n337 n338 1k
R339 n338 n339 1k
R340 n339 n340 1k
R341 n340 n341 1k
R342 n341 n342 1k
R343 n342 n343 1k
R344 n343 n344 1k
R345 n344 n345 1k
R346 n345 n346 1k
R347 n346 n347 1k
R348 n347 n348 1k
R349 n348 n349 1k
R350 n349 n350 1k
R351 n350 n351 1k
R352 n351 n352 1k
R353 n352 n353 1k
R354 n353 n354 1k
R355 n354 n355 1k
R356 n355 n356 1k
R357 n356 n357 1k
R358 n357 n358 1k
R359 n358 n359 1k
R360 n359 n360 1k
R361 n360 n361 1k
R362 n361 n362 1k
R363 n362 n363 1k
R364 n363 n364 1k
R365 n364 n365 1k
R366 n365 n366 1k
R367 n366 n367 1k
R368 n367 n368 1k
R369 n368 n369 1k
R370 n369 n370 1k
R371 n370 n371 1k
R372 n371 n372 1k
R373 n372 n373 1k
R374 n373 n374 1k
R375 n374 n375 1k
R376 n375 n376 1k
R377 n376 n377 1k
R378 n377 n378 1k
R379 n378 n379 1k
R380 n379 n380 1k
R381 n380 n381 1k
R382 n381 n382 1k
R383 n382 n383 1k
R384 n383 n384 1k
R385 n384 n385 1k
R386 n385 n386 1k
R387 n386 n387 1k
R388 n387 n388 1k
R389 n388 n389 1k
R390 n389 n390 1k
R391 n390 n391 1k
R392 n391 n392 1k
R393 n392 n393 1k
R394 n393 n394 1k
R395 n394 n395 1k
R396 n395 n396 1k
R397 n396 n397 1k
R398 n397 n398 1k
R399 n398 n399 1k
R400 n399 n400 1k
R401 n400 n401 1k
R402 n401 n402 1k
R403 n402 n403 1k
R404 n403 n404 1k
R405 n404 n405 1k
R406 n405 n406 1k
R407 n406 n407 1k
R408 n407 n408 1k
R409 n408 n409 1k
R410 n409 n410 1k
R411 n410 n411 1k
R412 n411 n412 1k
R413 n412 n413 1k
R414 n413 n414 1k
R415 n414 n415 1k
R416 n415 n416 1k
R417 n416 n417 1k
R418 n417 n418 1k
R419 n418 n419 1k
R420 n419 n420 1k
R421 n420 n421 1k
R422 n421 n422 1k
R423 n422 n423 1k
R424 n423 n424 1k
R425 n424 n425 1k
R426 n425 n426 1k
R427 n426 n427 1k
R428 n427 n428 1k
R429 n428 n429 1k
R430 n429 n430 1k
R431 n430 n431 1k
R432 n431 n432 1k
R433 n432 n433 1k
R434 n433 n434 1k
R435 n434 n435 1k
R436 n435 n436 1k
R437 n436 n437 1k
R438 n437 n438 1k
R439 n438 n439 1k
R440 n439 n440 1k
R441 n440 n441 1k
R442 n441 n442 1k
R443 n442 n443 1k
R444 n443 n444 1k
R445 n444 n445 1k
R446 n445 n446 1k
R447 n446 n447 1k
R448 n447 n448 1k
R449 n448 n449 1k
R450 n449 n450 1k
R451 n450 n451 1k
R452 n451 n452 1k
R453 n452 n453 1k
R454 n453 n454 1k
R455 n454 n455 1k
R456 n455 n456 1k
R457 n456 n457 1k
R458 n457 n458 1k
R459 n458 n459 1k
R460 n459 n460 1k
R461 n460 n461 1k
R462 n461 n462 1k
R463 n462 n463 1k
R464 n463 n464 1k
R465 n464 n465 1k
R466 n465 n466 1k
R467 n466 n467 1k
R468 n467 n468 1k
R469 n468 n469 1k
R470 n469 n470 1k
R471 n470 n471 1k
R472 n471 n472 1k
R473 n472 n473 1k
R474 n473 n474 1k
R475 n474 n475 1k
R476 n475 n476 1k
R477 n476 n477 1k
R478 n477 n478 1k
R479 n478 n479 1k
R480 n479 n480 1k
R481 n480 n481 1k
R482 n481 n482 1k
R483 n482 n483 1k
R484 n483 n484 1k
R485 n484 n485 1k
R486 n485 n486 1k
R487 n486 n487 1k
R488 n487 n488 1k
R489 n488 n489 1k
R490 n489 n490 1k
R491 n490 n491 1k
R492 n491 n492 1k
R493 n492 n493 1k
R494 n493 n494 1k
R495 n494 n495 1k
R496 n495 n496 1k
R497 n496 n497 1k
R498 n497 n498 1k
R499 n498 n499 1k
R500 n499 n500 1k
R501 n500 n501 1k
R502 n501 n502 1k
R503 n502 n503 1k
R504 n503 n504 1k
R505 n504 n505 1k
R506 n505 n506 1k
R507 n506 n507 1k
R508 n507 n508 1k
R509 n508 n509 1k
R510 n509 n510 1k
R511 n510 n511 1k
R512 n511 n512 1k
R513 n512 n513 1k
R514 n513 n514 1k
R515 n514 n515 1k
R516 n515 n516 1k
R517 n516 n517 1k
R518 n517 n518 1k
R519 n518 n519 1k
R520 n519 n520 1k
R521 n520 n521 1k
R522 n521 n522 1k
R523 n522 n523 1k
R524 n523 n524 1k
R525 n524 n525 1k
R526 n525 n526 1k
R527 n526 n527 1k
R528 n527 n528 1k
R529 n528 n529 1k
R530 n529 n530 1k
R531 n530 n531 1k
R532 n531 n532 1k
R533 n532 n533 1k
R534 n533 n534 1k
R535 n534 n535 1k
R536 n535 n536 1k
R537 n536 n537 1k
R538 n537 n538 1k
R539 n538 n539 1k
R540 n539 n540 1k
R541 n540 n541 1k
R542 n541 n542 1k
R543 n542 n543 1k
R544 n543 n544 1k
R545 n544 n545 1k
R546 n545 n546 1k
R547 n546 n547 1k
R548 n547 n548 1k
R549 n548 n549 1k
R550 n549 n550 1k
R551 n550 n551 1k
R552 n551 n552 1k
R553 n552 n553 1k
R554 n553 n554 1k
R555 n554 n555 1k
R556 n555 n556 1k
R557 n556 n557 1k
R558 n557 n558 1k
R559 n558 n559 1k
R560 n559 n560 1k
R561 n560 n561 1k
R562 n561 n562 1k
R563 n562 n563 1k
R564 n563 n564 1k
R565 n564 n565 1k
R566 n565 n566 1k
R567 n566 n567 1k
R568 n567 n568 1k
R569 n568 n569 1k
R570 n569 n570 1k
R571 n570 n571 1k
R572 n571 n572 1k
R573 n572 n573 1k
R574 n573 n574 1k
R575 n574 n575 1k
R576 n575 n576 1k
R577 n576 n577 1k
R578 n577 n578 1k
R579 n578 n579 1k
R580 n579 n580 1k
R581 n580 n581 1k
R582 n581 n582 1k
R583 n582 n583 1k
R584 n583 n584 1k
R585 n584 n585 1k
R586 n585 n586 1k
R587 n586 n587 1k
R588 n587 n588 1k
R589 n588 n589 1k
R590 n589 n590 1k
R591 n590 n591 1k
R592 n591 n592 1k
R593 n592 n593 1k
R594 n593 n594 1k
R595 n594 n595 1k
R596 n595 n596 1k
R597 n596 n597 1k
R598 n597 n598 1k
R599 n598 n599 1k
Rend n599 0 1k
.op
.end
