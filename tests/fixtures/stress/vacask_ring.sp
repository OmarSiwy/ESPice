* PSP103 wrappers and models
* Expected results: vacask_ring.expected.json
* Origin: benchmark/fixtures/vacask/ring/circuit.sp
* Instance names start with 'm' (SPICE device letter for MOSFETs).

.subckt nmos d g s b w=1u l=0.2u ld=0.5u ls=0.5u
  mn d g s b psp103n w={w} l={l} ad={w*ld} as={w*ls} pd={2*(w+ld)} ps={2*(w+ls)}
.ends

.subckt pmos d g s b w=1u l=0.2u ld=0.5u ls=0.5u
  mp d g s b psp103p w={w} l={l} ad={w*ld} as={w*ls} pd={2*(w+ld)} ps={2*(w+ls)}
.ends

.model psp103n NMOS(level=1040
+
+
+
+
+
+
+
+
+
+
+
+
+
+
+
+
+
+
+
+
+
+
+
+
+
+
+
+
+
+
+
+
+
+
+
+
+
+
+
+
+
+
+
+
+
+
+
+
+
+
+
+
+
+
+
+
+
+
+
+
+
+
+
+
+
+
+
+
+
+
+
+
+
+
+
+    uo=3.5e-2
+
+
+
+
+
+
+
+
+
+
+
+
+
+
+
+
+
+
+
+
+
+
+
+
+
+
+
+
+
+
+
+
+
+
+
+
+
+
+
+
+
+
+
+
+
+
+
+
+
+
+
+
+
+
+
+
+
+
+
+
+
+
+
+
+
+
+
+
+
+
+
+
+
+
+
+
+
+
+
+
+
+
+
+
+
+
+
+
+
+
+
+
+
+
+
+
+
+
+
+
+
+
+
+
+
+
+
+
+
+
+
+
+
+
+
+
+
+
+
+
+
+
+
+
+
+
+
+
+
+
+
+
+
+
+
+
+
+
+
+
+
+
+
+
+
+
+
+
+
+
+
+
+
+
+
+
+
+
+
+
+
+
+
+
+
+
+
+
+
+
+
+
+
+
+
+
+
+
+
+
+
+
+
+
+
+
+
+
+
+
+
+    )
.model psp103p PMOS(level=1040
+
+
+
+
+
+
+
+
+
+
+
+
+
+
+
+
+
+
+
+
+
+
+
+
+
+
+
+
+
+
+
+
+
+
+
+
+
+
+
+
+
+
+
+
+
+
+
+
+
+
+
+
+
+
+
+
+
+
+
+
+
+
+
+
+
+
+
+
+
+
+
+
+
+
+
+    uo=3.5e-2
+
+
+
+
+
+
+
+
+
+
+
+
+
+
+
+
+
+
+
+
+
+
+
+
+
+
+
+
+
+
+
+
+
+
+
+
+
+
+
+
+
+
+
+
+
+
+
+
+
+
+
+
+
+
+
+
+
+
+
+
+
+
+
+
+
+
+
+
+
+
+
+
+
+
+
+
+
+
+
+
+
+
+
+
+
+
+
+
+
+
+
+
+
+
+
+
+
+
+
+
+
+
+
+
+
+
+
+
+
+
+
+
+
+
+
+
+
+
+
+
+
+
+
+
+
+
+
+
+
+
+
+
+
+
+
+
+
+
+
+
+
+
+
+
+
+
+
+
+
+
+
+
+
+
+
+
+
+
+
+
+
+
+
+
+
+
+
+
+
+
+
+
+
+
+
+
+
+
+
+
+
+
+
+
+
+
+
+
+
+
+
+    )

* 9 stage CMOS ring oscillator (VACASK benchmark)
* 18 PSP MOSFETs, 1.2V supply

.subckt inverter in out vdd vss w=1u l=0.2u pfact=2
  xmp out in vdd vdd pmos w={w*pfact} l={l}
  xmn out in vss vss nmos w={w} l={l}
.ends

i0 0 1 dc 0 pulse 0 10u 1n 1n 1n 1n
xu1 1 2 vdd 0  inverter w={10u} l={1u}
xu2 2 3 vdd 0  inverter w={10u} l={1u}
xu3 3 4 vdd 0  inverter w={10u} l={1u}
xu4 4 5 vdd 0  inverter w={10u} l={1u}
xu5 5 6 vdd 0  inverter w={10u} l={1u}
xu6 6 7 vdd 0  inverter w={10u} l={1u}
xu7 7 8 vdd 0  inverter w={10u} l={1u}
xu8 8 9 vdd 0  inverter w={10u} l={1u}
xu9 9 1 vdd 0  inverter w={10u} l={1u}

vdd vdd 0 1.2

.options method=trap klu

.tran 0.05n 1u 0 0.05n

.end
