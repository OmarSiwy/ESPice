* Analysis directive alias envlp
* Expected results: envlp.expected.json
Vin out 0 2
R1 out 0 1k
.envlp 1m 3m
.end
