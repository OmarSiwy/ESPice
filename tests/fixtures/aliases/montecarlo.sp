* Analysis directive alias montecarlo
* Expected results: montecarlo.expected.json
Vin in 0 10
R1 in out 1000
R2 out 0 3000
.montecarlo 4 0
.end
