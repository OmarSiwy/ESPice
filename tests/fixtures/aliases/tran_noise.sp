* Analysis directive alias tran_noise
* Expected results: tran_noise.expected.json
Vin out 0 2
R1 out 0 1k
.tran_noise 1u 10u
.end
