* Ideal voltage source suppresses output voltage noise
* Expected results: clamped_output.expected.json
Vin out 0 AC 1
R1 out 0 1k
.noise v(out) Vin dec 4 10 10k
.end
