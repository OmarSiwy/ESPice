* Single noise frequency has zero integration bandwidth
* Expected results: single_frequency.expected.json
Vin in 0 DC 0 AC 1
R1 in out 1000
R2 out 0 3000
.noise v(out) Vin dec 4 100 100
.end
