* Frequency-shaped resistor noise and input referral
* Expected results: rc_1e-06.expected.json
Vin in 0 AC 1
R1 in out 1k
C1 out 0 1e-06
.noise v(out) Vin dec 4 10 10k
.end
