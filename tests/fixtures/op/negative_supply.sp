* negative supply
* Expected results: negative_supply.expected.json
Vin in 0 -12
R1 in out 2000
R2 out 0 1000
.op
.end
