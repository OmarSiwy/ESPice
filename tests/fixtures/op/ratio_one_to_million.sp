* ratio one to million
* Expected results: ratio_one_to_million.expected.json
Vin in 0 1
R1 in out 1
R2 out 0 1000000.0
.op
.end
