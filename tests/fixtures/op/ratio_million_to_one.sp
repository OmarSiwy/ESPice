* ratio million to one
* Expected results: ratio_million_to_one.expected.json
Vin in 0 1
R1 in out 1000000.0
R2 out 0 1
.op
.end
