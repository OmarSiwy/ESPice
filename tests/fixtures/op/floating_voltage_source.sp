* floating voltage source
* Expected results: floating_voltage_source.expected.json
V1 a b 3
R1 a 0 1k
R2 b 0 2k
.op
.end
