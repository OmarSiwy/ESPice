* inductor short dc
* Expected results: inductor_short_dc.expected.json
V1 in 0 3
R1 in out 1k
L1 out 0 1m
.op
.end
