* current withdrawal
* Expected results: current_withdrawal.expected.json
I1 out 0 1m
R1 out 0 2k
.op
.end
