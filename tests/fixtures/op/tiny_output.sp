* tiny output
* Expected results: tiny_output.expected.json
Vin in 0 1e-06
R1 in out 1000000.0
R2 out 0 1
.op
.end
