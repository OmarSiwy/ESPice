* vccs sign
* Expected results: vccs_sign.expected.json
Vin in 0 2
G1 out 0 in 0 1m
R1 out 0 2k
.op
.end
