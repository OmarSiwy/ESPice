* ccvs gain
* Expected results: ccvs_gain.expected.json
Vin in 0 2
Rin in sense 1k
Vsense sense 0 0
H1 out 0 Vsense 500
Rout out 0 1k
.op
.end
