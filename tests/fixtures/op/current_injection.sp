* current injection
* Expected results: current_injection.expected.json
I1 0 out 1m
R1 out 0 2k
.op
.end
