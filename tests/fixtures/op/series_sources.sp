* series sources
* Expected results: series_sources.expected.json
V1 a 0 2
V2 out a 3
R1 out 0 1k
.op
.end
