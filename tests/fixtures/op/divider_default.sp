* divider default
* Expected results: divider_default.expected.json
Vin in 0 10
R1 in out 1000
R2 out 0 3000
.op
.end
