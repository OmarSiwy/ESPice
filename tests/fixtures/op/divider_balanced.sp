* divider balanced
* Expected results: divider_balanced.expected.json
Vin in 0 1
R1 in out 1000
R2 out 0 1000
.op
.end
