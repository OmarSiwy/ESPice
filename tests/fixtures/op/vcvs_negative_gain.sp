* vcvs negative gain
* Expected results: vcvs_negative_gain.expected.json
Vin in 0 2
E1 out 0 in 0 -3
R1 out 0 1k
.op
.end
