* millivolt supply
* Expected results: millivolt_supply.expected.json
Vin in 0 0.001
R1 in out 1000
R2 out 0 3000
.op
.end
