* gigaohm load
* Expected results: gigaohm_load.expected.json
Vin in 0 1
R1 in out 1000000000.0
R2 out 0 3000000000.0
.op
.end
