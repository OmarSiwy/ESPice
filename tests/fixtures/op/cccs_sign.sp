* cccs sign
* Expected results: cccs_sign.expected.json
Vin in 0 2
Rin in sense 1k
Vsense sense 0 0
F1 out 0 Vsense 3
Rout out 0 1k
.op
.end
