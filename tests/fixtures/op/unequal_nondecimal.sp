* unequal nondecimal
* Expected results: unequal_nondecimal.expected.json
Vin in 0 3.3
R1 in out 2200
R2 out 0 4700
.op
.end
