* Static RG transmission line: derived classification and instance length alias.
Vin in 0 1
O1 in 0 out 0 line length=2
RL out 0 1
.model line LTRA r=1 g=1 len=1
.op
.end
