* kilovolt supply
* Expected results: kilovolt_supply.expected.json
Vin in 0 1000
R1 in out 1000000.0
R2 out 0 3000000.0
.op
.end
