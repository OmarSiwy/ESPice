* A .param chain 100 deep (#110): each link reads the one before;
* v(a) = 101. ngspice-45: a = 1.010000e+02.
.param p0=1
.param p1={p0+1}
.param p2={p1+1}
.param p3={p2+1}
.param p4={p3+1}
.param p5={p4+1}
.param p6={p5+1}
.param p7={p6+1}
.param p8={p7+1}
.param p9={p8+1}
.param p10={p9+1}
.param p11={p10+1}
.param p12={p11+1}
.param p13={p12+1}
.param p14={p13+1}
.param p15={p14+1}
.param p16={p15+1}
.param p17={p16+1}
.param p18={p17+1}
.param p19={p18+1}
.param p20={p19+1}
.param p21={p20+1}
.param p22={p21+1}
.param p23={p22+1}
.param p24={p23+1}
.param p25={p24+1}
.param p26={p25+1}
.param p27={p26+1}
.param p28={p27+1}
.param p29={p28+1}
.param p30={p29+1}
.param p31={p30+1}
.param p32={p31+1}
.param p33={p32+1}
.param p34={p33+1}
.param p35={p34+1}
.param p36={p35+1}
.param p37={p36+1}
.param p38={p37+1}
.param p39={p38+1}
.param p40={p39+1}
.param p41={p40+1}
.param p42={p41+1}
.param p43={p42+1}
.param p44={p43+1}
.param p45={p44+1}
.param p46={p45+1}
.param p47={p46+1}
.param p48={p47+1}
.param p49={p48+1}
.param p50={p49+1}
.param p51={p50+1}
.param p52={p51+1}
.param p53={p52+1}
.param p54={p53+1}
.param p55={p54+1}
.param p56={p55+1}
.param p57={p56+1}
.param p58={p57+1}
.param p59={p58+1}
.param p60={p59+1}
.param p61={p60+1}
.param p62={p61+1}
.param p63={p62+1}
.param p64={p63+1}
.param p65={p64+1}
.param p66={p65+1}
.param p67={p66+1}
.param p68={p67+1}
.param p69={p68+1}
.param p70={p69+1}
.param p71={p70+1}
.param p72={p71+1}
.param p73={p72+1}
.param p74={p73+1}
.param p75={p74+1}
.param p76={p75+1}
.param p77={p76+1}
.param p78={p77+1}
.param p79={p78+1}
.param p80={p79+1}
.param p81={p80+1}
.param p82={p81+1}
.param p83={p82+1}
.param p84={p83+1}
.param p85={p84+1}
.param p86={p85+1}
.param p87={p86+1}
.param p88={p87+1}
.param p89={p88+1}
.param p90={p89+1}
.param p91={p90+1}
.param p92={p91+1}
.param p93={p92+1}
.param p94={p93+1}
.param p95={p94+1}
.param p96={p95+1}
.param p97={p96+1}
.param p98={p97+1}
.param p99={p98+1}
.param p100={p99+1}
V1 a 0 {p100}
R1 a 0 1k
.op
.end
