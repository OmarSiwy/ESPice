* parallel resistors
* Expected results: parallel_resistors.expected.json
V1 in 0 1
R1 in out 1k
R2 out 0 2k
R3 out 0 2k
.op
.end
