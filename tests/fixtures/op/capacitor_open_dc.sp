* capacitor open dc
* Expected results: capacitor_open_dc.expected.json
V1 in 0 3
R1 in out 1k
C1 out 0 1u
.op
.end
