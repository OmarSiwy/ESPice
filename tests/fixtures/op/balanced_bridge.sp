* balanced bridge
* Expected results: balanced_bridge.expected.json
V1 in 0 10
R1 in a 1k
R2 a 0 1k
R3 in b 2k
R4 b 0 2k
R5 a b 7
.op
.end
