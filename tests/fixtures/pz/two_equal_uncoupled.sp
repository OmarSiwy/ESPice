* Repeated eigenvalue with two independent states
* Expected results: two_equal_uncoupled.expected.json
Vin in 0 0
R1 in a 1k
C1 a 0 1u
R2 in b 1k
C2 b 0 1u
.pz
.end
