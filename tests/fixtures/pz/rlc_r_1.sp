* RLC poles across under-, critical-, and overdamping
* Expected results: rlc_r_1.expected.json
Vin in 0 0
R1 in a 1
L1 a out 1m
C1 out 0 1u
.pz
.end
