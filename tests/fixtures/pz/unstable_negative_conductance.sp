* Unstable pole must not be hidden
* Expected results: unstable_negative_conductance.expected.json
R1 out 0 1k
G1 out 0 out 0 -.002
C1 out 0 1u
.pz
.end
