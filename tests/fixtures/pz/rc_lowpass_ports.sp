* Transfer poles and zeros with explicit input and output ports
* Expected results: rc_lowpass_ports.expected.json
Vin in 0 0
R1 in out 1k
C1 out 0 1u
.pz in 0 out 0 vol pz
.end
