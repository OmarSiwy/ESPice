* Transfer poles and zeros with explicit input and output ports
* Expected results: rc_highpass_zero.expected.json
Vin in 0 0
C1 in out 1u
R1 out 0 1k
.pz in 0 out 0 vol pz
.end
