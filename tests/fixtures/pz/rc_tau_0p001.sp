* Single RC pole
* Expected results: rc_tau_0p001.expected.json
Vin in 0 0
R1 in out 1k
C1 out 0 1e-06
.pz
.end
