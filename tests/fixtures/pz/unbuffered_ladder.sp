* Coupled two-state RC ladder
* Expected results: unbuffered_ladder.expected.json
Vin in 0 0
R1 in a 1k
C1 a 0 1u
R2 a out 1k
C2 out 0 1u
.pz
.end
