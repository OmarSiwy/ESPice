* Retain poles separated by twelve orders of magnitude
* Expected results: widely_separated_modes.expected.json
Vin in 0 0
R1 in a 1k
C1 a 0 1p
R2 in b 1k
C2 b 0 1
.pz
.end
