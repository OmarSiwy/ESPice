* Single RC pole
* Expected results: rc_tau_1000.expected.json
Vin in 0 0
R1 in out 1k
C1 out 0 1
.pz
.end
