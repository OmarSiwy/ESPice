* RLC poles across under-, critical-, and overdamping
* Expected results: rlc_r_63p2456.expected.json
Vin in 0 0
R1 in a 63.24555320336759
L1 a out 1m
C1 out 0 1u
.pz
.end
