* Noise cannot perturb an ideal voltage constraint
* Expected results: ideal_clamp_2.expected.json
Vin out 0 2
R1 out 0 1k
.trannoise 1u 100u
.end
