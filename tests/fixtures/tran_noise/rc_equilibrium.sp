* Stationary RC thermal noise variance
* Expected results: rc_equilibrium.expected.json
R1 out 0 1k
C1 out 0 1p
.trannoise 50p 10u
.end
