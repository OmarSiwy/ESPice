* Noise cannot perturb an ideal voltage constraint
* Expected results: ideal_clamp_0.expected.json
Vin out 0 0
R1 out 0 1k
.trannoise 1u 100u
.end
