* Capacitor is open at DC, so no finite DC operating point exists.
* Expected results: current_into_capacitor_dc.expected.json
I1 0 out 1m
C1 out 0 1u
.op
.end
