* Transient stop time must be positive.
* Expected results: tran_negative_stop.expected.json
Vin in 0 1
R1 in out 1k
R2 out 0 1k
.tran 1u -1m
.end
