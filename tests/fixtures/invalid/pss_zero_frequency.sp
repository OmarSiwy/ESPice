* Periodic steady state requires a positive fundamental frequency.
* Expected results: pss_zero_frequency.expected.json
Vin in 0 1
R1 in out 1k
R2 out 0 1k
.pss 0
.end
