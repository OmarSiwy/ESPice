* Monte Carlo trial count must be integral.
* Expected results: mc_fractional_trials.expected.json
Vin in 0 1
R1 in out 1k
R2 out 0 1k
.mc 2.5
.end
