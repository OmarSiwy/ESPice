* Transfer input must identify an existing independent source.
* Expected results: tf_missing_source.expected.json
Vin in 0 1
R1 in out 1k
R2 out 0 1k
.tf v(out) Missing
.end
