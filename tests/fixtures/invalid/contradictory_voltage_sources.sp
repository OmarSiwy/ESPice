* Parallel ideal sources impose contradictory voltages.
* Expected results: contradictory_voltage_sources.expected.json
V1 out 0 1
V2 out 0 2
R1 out 0 1k
.op
.end
