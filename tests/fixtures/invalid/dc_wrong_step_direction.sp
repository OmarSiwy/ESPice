* Step direction must approach the requested stop.
* Expected results: dc_wrong_step_direction.expected.json
Vin in 0 1
R1 in out 1k
R2 out 0 1k
.dc Vin 0 1 -.1
.end
