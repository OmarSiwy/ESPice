* A zero point density cannot define a sweep.
* Expected results: ac_zero_density.expected.json
Vin in 0 1
R1 in out 1k
R2 out 0 1k
.ac dec 0 1 100
.end
