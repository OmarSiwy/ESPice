* Harmonic balance fundamental must be positive.
* Expected results: hb_negative_frequency.expected.json
Vin in 0 1
R1 in out 1k
R2 out 0 1k
.hb -1k
.end
