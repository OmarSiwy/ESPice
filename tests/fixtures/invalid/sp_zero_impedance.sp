* Power-wave reference impedance must be positive.
* Expected results: sp_zero_impedance.expected.json
Vp out 0 0 portnum 1 z0 0
R1 out 0 50
.sp dec 3 10 100
.end
