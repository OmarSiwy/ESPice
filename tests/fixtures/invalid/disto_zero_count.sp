* Distortion sweep point density must be positive.
* Expected results: disto_zero_count.expected.json
Vin in 0 1
R1 in out 1k
R2 out 0 1k
.disto dec 0 10 100
.end
