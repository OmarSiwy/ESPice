* Transfer output node must exist.
* Expected results: tf_missing_output.expected.json
Vin in 0 1
R1 in out 1k
R2 out 0 1k
.tf v(missing) Vin
.end
