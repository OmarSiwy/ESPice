* Every requested temperature must be physically valid.
* Expected results: temp_below_absolute_zero.expected.json
Vin in 0 1
R1 in out 1k
R2 out 0 1k
.temp -300 20 10
.end
