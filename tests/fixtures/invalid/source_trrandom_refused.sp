* TRRANDOM is refused naming the card, not run as its DC value (#72).
V1 a 0 dc 0 trrandom(2 10n 0 1 0)
R1 a 0 1k
.tran 1n 1u
.end
