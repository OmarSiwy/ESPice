* PXF pump frequency must be positive.
* Expected results: pxf_zero_lo.expected.json
Vin in 0 1
R1 in out 1k
R2 out 0 1k
.pxf 0 dec 4 10 100
.end
