* Harmonic order must be an integer.
* Expected results: hb_fractional_harmonics.expected.json
Vin in 0 1
R1 in out 1k
R2 out 0 1k
.hb 1k 1.5
.end
