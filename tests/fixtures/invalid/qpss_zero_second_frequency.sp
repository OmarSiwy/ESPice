* Both QPSS fundamental frequencies must be positive.
* Expected results: qpss_zero_second_frequency.expected.json
Vin in 0 1
R1 in out 1k
R2 out 0 1k
.qpss 1k 0 2 2
.end
