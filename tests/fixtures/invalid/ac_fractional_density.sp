* Frequency point counts must be integers.
* Expected results: ac_fractional_density.expected.json
Vin in 0 1
R1 in out 1k
R2 out 0 1k
.ac dec 1.5 1 100
.end
