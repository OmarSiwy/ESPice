* Monte Carlo requires at least one trial.
* Expected results: mc_zero_trials.expected.json
Vin in 0 1
R1 in out 1k
R2 out 0 1k
.mc 0
.end
