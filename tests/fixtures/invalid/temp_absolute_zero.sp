* Device temperature must be greater than absolute zero.
* Expected results: temp_absolute_zero.expected.json
Vin in 0 1
R1 in out 1k
R2 out 0 1k
.temp -273.15
.op
.end
