* Periodic sample count must be positive.
* Expected results: pss_negative_samples.expected.json
Vin in 0 1
R1 in out 1k
R2 out 0 1k
.pss 1k -4
.end
