* Matrix-exponential output interval must be positive.
* Expected results: matex_negative_step.expected.json
Vin in 0 1
R1 in out 1k
R2 out 0 1k
.matex -1u 1m
.end
