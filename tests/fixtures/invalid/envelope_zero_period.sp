* Carrier period must be positive.
* Expected results: envelope_zero_period.expected.json
Vin in 0 1
R1 in out 1k
R2 out 0 1k
.envelope 0 1m
.end
