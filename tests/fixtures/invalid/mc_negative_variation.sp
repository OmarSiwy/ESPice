* Standard deviation cannot be negative.
* Expected results: mc_negative_variation.expected.json
Vin in 0 1
R1 in out 1k
R2 out 0 1k
.mc 10 -.1
.end
