* MOSFET LEVEL 57 (BSIMSOI-PD) is not in the device catalog: the refusal
* names the card and maps to unsupported input (#75).
VD d 0 1
M1 d d 0 0 m57
.model m57 nmos level=57
.op
.end
