* Transient output step must be positive.
* Expected results: tran_zero_step.expected.json
Vin in 0 1
R1 in out 1k
R2 out 0 1k
.tran 0 1m
.end
