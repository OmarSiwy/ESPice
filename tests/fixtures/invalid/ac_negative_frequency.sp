* Logarithmic frequencies must be positive.
* Expected results: ac_negative_frequency.expected.json
Vin in 0 1
R1 in out 1k
R2 out 0 1k
.ac dec 10 -1 100
.end
