* Sensitivity output node must exist.
* Expected results: sens_unknown_node.expected.json
Vin in 0 1
R1 in out 1k
R2 out 0 1k
.sens v(missing)
.end
