* Temperature sweep step cannot be zero.
* Expected results: temp_zero_step.expected.json
Vin in 0 1
R1 in out 1k
R2 out 0 1k
.temp 0 100 0
.end
