* No branch can carry the injected DC current.
* Expected results: current_into_open_node.expected.json
I1 0 out 1m
.op
.end
