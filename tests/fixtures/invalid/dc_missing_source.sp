* Sweep target must identify an existing source or parameter.
* Expected results: dc_missing_source.expected.json
Vin in 0 1
R1 in out 1k
R2 out 0 1k
.dc Missing 0 1 .1
.end
