* Ideal voltage loop violates KVL.
* Expected results: contradictory_voltage_loop.expected.json
V1 a 0 1
V2 b a 1
V3 b 0 3
R1 b 0 1k
.op
.end
