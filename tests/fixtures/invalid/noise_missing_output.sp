* Noise output node must exist.
* Expected results: noise_missing_output.expected.json
Vin in 0 1
R1 in out 1k
R2 out 0 1k
.noise v(missing) Vin dec 10 1 100
.end
