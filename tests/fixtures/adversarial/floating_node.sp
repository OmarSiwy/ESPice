* Floating node — node 3 has no path to ground
V1 1 0 DC 5
R1 1 2 1k
R2 2 0 1k
R3 2 3 1k
.OP
.END
