* Zero resistance — singular matrix
V1 1 0 DC 5
R1 1 2 0
R2 2 0 1k
.OP
.END
