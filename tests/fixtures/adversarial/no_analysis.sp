* Circuit with no analysis statement
V1 1 0 DC 5
R1 1 0 1k
.END
