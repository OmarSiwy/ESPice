* Duplicate device names
V1 1 0 DC 5
R1 1 2 1k
R1 2 0 1k
.OP
.END
