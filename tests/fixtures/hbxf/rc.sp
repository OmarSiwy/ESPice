* HB XF adjoint output-node current injection transfer
* Expected results: rc.expected.json
Vin in 0 AC 1 SIN(0 1 1k)
R1 in out 1k
C1 out 0 1u
.hbxf v(out) dec 4 10 10k 1k 3
.end
