* Transfer function divider
* Expected results: divider.expected.json
Vin in 0 10
R1 in out 1000
R2 out 0 3000
.tf v(out) Vin
.end
