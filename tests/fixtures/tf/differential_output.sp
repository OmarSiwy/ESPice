* Differential transfer function and differential output resistance
* Expected results: differential_output.expected.json
Vin in 0 1
R1 in a 1k
R2 a 0 3k
R3 in b 3k
R4 b 0 1k
.tf v(a,b) Vin
.end
