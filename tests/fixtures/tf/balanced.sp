* Transfer function balanced
* Expected results: balanced.expected.json
Vin in 0 0
R1 in out 1000
R2 out 0 1000
.tf v(out) Vin
.end
