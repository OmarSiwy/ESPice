* Transfer function negative_bias
* Expected results: negative_bias.expected.json
Vin in 0 -3
R1 in out 2200
R2 out 0 4700
.tf v(out) Vin
.end
