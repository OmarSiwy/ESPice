* TF source selection with an earlier bias supply
* Expected results: second_source.expected.json
Vbias bias 0 3
Vin in 0 2
R1 in out 1k
R2 out bias 3k
.tf v(out) Vin
.end
