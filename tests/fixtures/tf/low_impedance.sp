* Transfer function low_impedance
* Expected results: low_impedance.expected.json
Vin in 0 1
R1 in out 0.001
R2 out 0 0.003
.tf v(out) Vin
.end
