* Ideal source clamps output resistance to zero
* Expected results: ideal_voltage_output.expected.json
Vin out 0 3
R1 out 0 1k
.tf v(out) Vin
.end
