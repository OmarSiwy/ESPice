* Current-output DC transconductance
* Expected results: current_output.expected.json
Vin in 0 1
R1 in out 1k
Vmeasure out 0 0
.tf i(Vmeasure) Vin
.end
