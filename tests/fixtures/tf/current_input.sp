* Current-input DC transimpedance
* Expected results: current_input.expected.json
Iin 0 out 1m
R1 out 0 2k
.tf v(out) Iin
.end
