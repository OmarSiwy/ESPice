* Simple Resistor DC Sweep
* Voltage divider: V(out) = V1 * R2/(R1+R2)

V1 in 0 DC 0
R1 in out 1k
R2 out 0 2k

.DC V1 -5 5 0.1

.END
