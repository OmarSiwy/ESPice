* Nested DC Sweep with Temperature
* Resistor divider with temperature coefficient, swept over voltage and temperature

V1 in 0 DC 0
R1 in out 1k TC=0.01
R2 out 0 1k

.DC V1 0 5 0.1 TEMP 0 100 25

.END
