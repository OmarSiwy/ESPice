* Gaussian Monte Carlo population statistics
* Expected results: gaussian_source.expected.json
Vin out 0 1
R1 out 0 1k
.mc 4096 .05
.end
