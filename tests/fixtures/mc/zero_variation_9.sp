* Zero-variance Monte Carlo and structural lane tails
* Expected results: zero_variation_9.expected.json
Vin in 0 10
R1 in out 1000
R2 out 0 3000
.mc 9 0
.end
