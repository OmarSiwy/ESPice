* Q03: Resistor Divider DC Sweep — V(out) = V1 * R2/(R1+R2)
V1 in 0 DC 1
R1 in out 1k
R2 out 0 1k
.DC V1 0 5 0.1
.END
