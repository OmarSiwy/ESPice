* Q04: AC Impedance Test — R in series with parallel LC tank
V1 in 0 DC 0 AC 1
R1 in out 100
L1 out 0 10u
C1 out 0 100n
.AC DEC 20 1k 100MEG
.END
