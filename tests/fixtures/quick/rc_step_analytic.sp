* Q01: RC Step Response — v(out) = V0*(1 - exp(-t/RC)), tau = 1ns
V1 in 0 DC 1
R1 in out 1k
C1 out 0 1n
.TRAN 0.1n 10n
.END
