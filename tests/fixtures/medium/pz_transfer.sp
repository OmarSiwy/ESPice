* M12: Pole-Zero of RLC Bandpass — series RLC with shunt load
V1 in 0 DC 0 AC 1
R1 in mid 50
L1 mid out 1u
C1 out 0 1n
R2 out 0 10k
.PZ V(out) V1 CUR POL
.PZ V(out) V1 CUR ZER
.END
