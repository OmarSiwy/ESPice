* M17: AC Sensitivity of Two-Stage RC Filter — complex sensitivities
V1 in 0 DC 0 AC 1
R1 in mid 1k
C1 mid 0 10n
R2 mid out 1k
C2 out 0 10n
.AC DEC 10 1k 100MEG
.SENS V(out)
.END
