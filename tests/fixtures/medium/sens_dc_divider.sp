* M16: DC Sensitivity of Voltage Divider — V(out) sensitivity to R1, R2
V1 in 0 DC 5
R1 in out 1k
R2 out 0 1k
.SENS V(out)
.END
