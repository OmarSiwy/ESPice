* CMOS Inverter Chain — 1000 stages
VDD vdd 0 DC 3.3
VIN in 0 PULSE(0 3.3 1n 0.5n 0.5n 10n 20n)

.MODEL NMOD NMOS (VTO=0.5 KP=120u)
.MODEL PMOD PMOS (VTO=-0.5 KP=60u)

Mn1 n1 in 0 0 NMOD W=10u L=1u
Mp1 n1 in vdd vdd PMOD W=20u L=1u
CL1 n1 0 0.01p
Mn2 n2 n1 0 0 NMOD W=10u L=1u
Mp2 n2 n1 vdd vdd PMOD W=20u L=1u
CL2 n2 0 0.01p
Mn3 n3 n2 0 0 NMOD W=10u L=1u
Mp3 n3 n2 vdd vdd PMOD W=20u L=1u
CL3 n3 0 0.01p
Mn4 n4 n3 0 0 NMOD W=10u L=1u
Mp4 n4 n3 vdd vdd PMOD W=20u L=1u
CL4 n4 0 0.01p
Mn5 n5 n4 0 0 NMOD W=10u L=1u
Mp5 n5 n4 vdd vdd PMOD W=20u L=1u
CL5 n5 0 0.01p
Mn6 n6 n5 0 0 NMOD W=10u L=1u
Mp6 n6 n5 vdd vdd PMOD W=20u L=1u
CL6 n6 0 0.01p
Mn7 n7 n6 0 0 NMOD W=10u L=1u
Mp7 n7 n6 vdd vdd PMOD W=20u L=1u
CL7 n7 0 0.01p
Mn8 n8 n7 0 0 NMOD W=10u L=1u
Mp8 n8 n7 vdd vdd PMOD W=20u L=1u
CL8 n8 0 0.01p
Mn9 n9 n8 0 0 NMOD W=10u L=1u
Mp9 n9 n8 vdd vdd PMOD W=20u L=1u
CL9 n9 0 0.01p
Mn10 n10 n9 0 0 NMOD W=10u L=1u
Mp10 n10 n9 vdd vdd PMOD W=20u L=1u
CL10 n10 0 0.01p
Mn11 n11 n10 0 0 NMOD W=10u L=1u
Mp11 n11 n10 vdd vdd PMOD W=20u L=1u
CL11 n11 0 0.01p
Mn12 n12 n11 0 0 NMOD W=10u L=1u
Mp12 n12 n11 vdd vdd PMOD W=20u L=1u
CL12 n12 0 0.01p
Mn13 n13 n12 0 0 NMOD W=10u L=1u
Mp13 n13 n12 vdd vdd PMOD W=20u L=1u
CL13 n13 0 0.01p
Mn14 n14 n13 0 0 NMOD W=10u L=1u
Mp14 n14 n13 vdd vdd PMOD W=20u L=1u
CL14 n14 0 0.01p
Mn15 n15 n14 0 0 NMOD W=10u L=1u
Mp15 n15 n14 vdd vdd PMOD W=20u L=1u
CL15 n15 0 0.01p
Mn16 n16 n15 0 0 NMOD W=10u L=1u
Mp16 n16 n15 vdd vdd PMOD W=20u L=1u
CL16 n16 0 0.01p
Mn17 n17 n16 0 0 NMOD W=10u L=1u
Mp17 n17 n16 vdd vdd PMOD W=20u L=1u
CL17 n17 0 0.01p
Mn18 n18 n17 0 0 NMOD W=10u L=1u
Mp18 n18 n17 vdd vdd PMOD W=20u L=1u
CL18 n18 0 0.01p
Mn19 n19 n18 0 0 NMOD W=10u L=1u
Mp19 n19 n18 vdd vdd PMOD W=20u L=1u
CL19 n19 0 0.01p
Mn20 n20 n19 0 0 NMOD W=10u L=1u
Mp20 n20 n19 vdd vdd PMOD W=20u L=1u
CL20 n20 0 0.01p
Mn21 n21 n20 0 0 NMOD W=10u L=1u
Mp21 n21 n20 vdd vdd PMOD W=20u L=1u
CL21 n21 0 0.01p
Mn22 n22 n21 0 0 NMOD W=10u L=1u
Mp22 n22 n21 vdd vdd PMOD W=20u L=1u
CL22 n22 0 0.01p
Mn23 n23 n22 0 0 NMOD W=10u L=1u
Mp23 n23 n22 vdd vdd PMOD W=20u L=1u
CL23 n23 0 0.01p
Mn24 n24 n23 0 0 NMOD W=10u L=1u
Mp24 n24 n23 vdd vdd PMOD W=20u L=1u
CL24 n24 0 0.01p
Mn25 n25 n24 0 0 NMOD W=10u L=1u
Mp25 n25 n24 vdd vdd PMOD W=20u L=1u
CL25 n25 0 0.01p
Mn26 n26 n25 0 0 NMOD W=10u L=1u
Mp26 n26 n25 vdd vdd PMOD W=20u L=1u
CL26 n26 0 0.01p
Mn27 n27 n26 0 0 NMOD W=10u L=1u
Mp27 n27 n26 vdd vdd PMOD W=20u L=1u
CL27 n27 0 0.01p
Mn28 n28 n27 0 0 NMOD W=10u L=1u
Mp28 n28 n27 vdd vdd PMOD W=20u L=1u
CL28 n28 0 0.01p
Mn29 n29 n28 0 0 NMOD W=10u L=1u
Mp29 n29 n28 vdd vdd PMOD W=20u L=1u
CL29 n29 0 0.01p
Mn30 n30 n29 0 0 NMOD W=10u L=1u
Mp30 n30 n29 vdd vdd PMOD W=20u L=1u
CL30 n30 0 0.01p
Mn31 n31 n30 0 0 NMOD W=10u L=1u
Mp31 n31 n30 vdd vdd PMOD W=20u L=1u
CL31 n31 0 0.01p
Mn32 n32 n31 0 0 NMOD W=10u L=1u
Mp32 n32 n31 vdd vdd PMOD W=20u L=1u
CL32 n32 0 0.01p
Mn33 n33 n32 0 0 NMOD W=10u L=1u
Mp33 n33 n32 vdd vdd PMOD W=20u L=1u
CL33 n33 0 0.01p
Mn34 n34 n33 0 0 NMOD W=10u L=1u
Mp34 n34 n33 vdd vdd PMOD W=20u L=1u
CL34 n34 0 0.01p
Mn35 n35 n34 0 0 NMOD W=10u L=1u
Mp35 n35 n34 vdd vdd PMOD W=20u L=1u
CL35 n35 0 0.01p
Mn36 n36 n35 0 0 NMOD W=10u L=1u
Mp36 n36 n35 vdd vdd PMOD W=20u L=1u
CL36 n36 0 0.01p
Mn37 n37 n36 0 0 NMOD W=10u L=1u
Mp37 n37 n36 vdd vdd PMOD W=20u L=1u
CL37 n37 0 0.01p
Mn38 n38 n37 0 0 NMOD W=10u L=1u
Mp38 n38 n37 vdd vdd PMOD W=20u L=1u
CL38 n38 0 0.01p
Mn39 n39 n38 0 0 NMOD W=10u L=1u
Mp39 n39 n38 vdd vdd PMOD W=20u L=1u
CL39 n39 0 0.01p
Mn40 n40 n39 0 0 NMOD W=10u L=1u
Mp40 n40 n39 vdd vdd PMOD W=20u L=1u
CL40 n40 0 0.01p
Mn41 n41 n40 0 0 NMOD W=10u L=1u
Mp41 n41 n40 vdd vdd PMOD W=20u L=1u
CL41 n41 0 0.01p
Mn42 n42 n41 0 0 NMOD W=10u L=1u
Mp42 n42 n41 vdd vdd PMOD W=20u L=1u
CL42 n42 0 0.01p
Mn43 n43 n42 0 0 NMOD W=10u L=1u
Mp43 n43 n42 vdd vdd PMOD W=20u L=1u
CL43 n43 0 0.01p
Mn44 n44 n43 0 0 NMOD W=10u L=1u
Mp44 n44 n43 vdd vdd PMOD W=20u L=1u
CL44 n44 0 0.01p
Mn45 n45 n44 0 0 NMOD W=10u L=1u
Mp45 n45 n44 vdd vdd PMOD W=20u L=1u
CL45 n45 0 0.01p
Mn46 n46 n45 0 0 NMOD W=10u L=1u
Mp46 n46 n45 vdd vdd PMOD W=20u L=1u
CL46 n46 0 0.01p
Mn47 n47 n46 0 0 NMOD W=10u L=1u
Mp47 n47 n46 vdd vdd PMOD W=20u L=1u
CL47 n47 0 0.01p
Mn48 n48 n47 0 0 NMOD W=10u L=1u
Mp48 n48 n47 vdd vdd PMOD W=20u L=1u
CL48 n48 0 0.01p
Mn49 n49 n48 0 0 NMOD W=10u L=1u
Mp49 n49 n48 vdd vdd PMOD W=20u L=1u
CL49 n49 0 0.01p
Mn50 n50 n49 0 0 NMOD W=10u L=1u
Mp50 n50 n49 vdd vdd PMOD W=20u L=1u
CL50 n50 0 0.01p
Mn51 n51 n50 0 0 NMOD W=10u L=1u
Mp51 n51 n50 vdd vdd PMOD W=20u L=1u
CL51 n51 0 0.01p
Mn52 n52 n51 0 0 NMOD W=10u L=1u
Mp52 n52 n51 vdd vdd PMOD W=20u L=1u
CL52 n52 0 0.01p
Mn53 n53 n52 0 0 NMOD W=10u L=1u
Mp53 n53 n52 vdd vdd PMOD W=20u L=1u
CL53 n53 0 0.01p
Mn54 n54 n53 0 0 NMOD W=10u L=1u
Mp54 n54 n53 vdd vdd PMOD W=20u L=1u
CL54 n54 0 0.01p
Mn55 n55 n54 0 0 NMOD W=10u L=1u
Mp55 n55 n54 vdd vdd PMOD W=20u L=1u
CL55 n55 0 0.01p
Mn56 n56 n55 0 0 NMOD W=10u L=1u
Mp56 n56 n55 vdd vdd PMOD W=20u L=1u
CL56 n56 0 0.01p
Mn57 n57 n56 0 0 NMOD W=10u L=1u
Mp57 n57 n56 vdd vdd PMOD W=20u L=1u
CL57 n57 0 0.01p
Mn58 n58 n57 0 0 NMOD W=10u L=1u
Mp58 n58 n57 vdd vdd PMOD W=20u L=1u
CL58 n58 0 0.01p
Mn59 n59 n58 0 0 NMOD W=10u L=1u
Mp59 n59 n58 vdd vdd PMOD W=20u L=1u
CL59 n59 0 0.01p
Mn60 n60 n59 0 0 NMOD W=10u L=1u
Mp60 n60 n59 vdd vdd PMOD W=20u L=1u
CL60 n60 0 0.01p
Mn61 n61 n60 0 0 NMOD W=10u L=1u
Mp61 n61 n60 vdd vdd PMOD W=20u L=1u
CL61 n61 0 0.01p
Mn62 n62 n61 0 0 NMOD W=10u L=1u
Mp62 n62 n61 vdd vdd PMOD W=20u L=1u
CL62 n62 0 0.01p
Mn63 n63 n62 0 0 NMOD W=10u L=1u
Mp63 n63 n62 vdd vdd PMOD W=20u L=1u
CL63 n63 0 0.01p
Mn64 n64 n63 0 0 NMOD W=10u L=1u
Mp64 n64 n63 vdd vdd PMOD W=20u L=1u
CL64 n64 0 0.01p
Mn65 n65 n64 0 0 NMOD W=10u L=1u
Mp65 n65 n64 vdd vdd PMOD W=20u L=1u
CL65 n65 0 0.01p
Mn66 n66 n65 0 0 NMOD W=10u L=1u
Mp66 n66 n65 vdd vdd PMOD W=20u L=1u
CL66 n66 0 0.01p
Mn67 n67 n66 0 0 NMOD W=10u L=1u
Mp67 n67 n66 vdd vdd PMOD W=20u L=1u
CL67 n67 0 0.01p
Mn68 n68 n67 0 0 NMOD W=10u L=1u
Mp68 n68 n67 vdd vdd PMOD W=20u L=1u
CL68 n68 0 0.01p
Mn69 n69 n68 0 0 NMOD W=10u L=1u
Mp69 n69 n68 vdd vdd PMOD W=20u L=1u
CL69 n69 0 0.01p
Mn70 n70 n69 0 0 NMOD W=10u L=1u
Mp70 n70 n69 vdd vdd PMOD W=20u L=1u
CL70 n70 0 0.01p
Mn71 n71 n70 0 0 NMOD W=10u L=1u
Mp71 n71 n70 vdd vdd PMOD W=20u L=1u
CL71 n71 0 0.01p
Mn72 n72 n71 0 0 NMOD W=10u L=1u
Mp72 n72 n71 vdd vdd PMOD W=20u L=1u
CL72 n72 0 0.01p
Mn73 n73 n72 0 0 NMOD W=10u L=1u
Mp73 n73 n72 vdd vdd PMOD W=20u L=1u
CL73 n73 0 0.01p
Mn74 n74 n73 0 0 NMOD W=10u L=1u
Mp74 n74 n73 vdd vdd PMOD W=20u L=1u
CL74 n74 0 0.01p
Mn75 n75 n74 0 0 NMOD W=10u L=1u
Mp75 n75 n74 vdd vdd PMOD W=20u L=1u
CL75 n75 0 0.01p
Mn76 n76 n75 0 0 NMOD W=10u L=1u
Mp76 n76 n75 vdd vdd PMOD W=20u L=1u
CL76 n76 0 0.01p
Mn77 n77 n76 0 0 NMOD W=10u L=1u
Mp77 n77 n76 vdd vdd PMOD W=20u L=1u
CL77 n77 0 0.01p
Mn78 n78 n77 0 0 NMOD W=10u L=1u
Mp78 n78 n77 vdd vdd PMOD W=20u L=1u
CL78 n78 0 0.01p
Mn79 n79 n78 0 0 NMOD W=10u L=1u
Mp79 n79 n78 vdd vdd PMOD W=20u L=1u
CL79 n79 0 0.01p
Mn80 n80 n79 0 0 NMOD W=10u L=1u
Mp80 n80 n79 vdd vdd PMOD W=20u L=1u
CL80 n80 0 0.01p
Mn81 n81 n80 0 0 NMOD W=10u L=1u
Mp81 n81 n80 vdd vdd PMOD W=20u L=1u
CL81 n81 0 0.01p
Mn82 n82 n81 0 0 NMOD W=10u L=1u
Mp82 n82 n81 vdd vdd PMOD W=20u L=1u
CL82 n82 0 0.01p
Mn83 n83 n82 0 0 NMOD W=10u L=1u
Mp83 n83 n82 vdd vdd PMOD W=20u L=1u
CL83 n83 0 0.01p
Mn84 n84 n83 0 0 NMOD W=10u L=1u
Mp84 n84 n83 vdd vdd PMOD W=20u L=1u
CL84 n84 0 0.01p
Mn85 n85 n84 0 0 NMOD W=10u L=1u
Mp85 n85 n84 vdd vdd PMOD W=20u L=1u
CL85 n85 0 0.01p
Mn86 n86 n85 0 0 NMOD W=10u L=1u
Mp86 n86 n85 vdd vdd PMOD W=20u L=1u
CL86 n86 0 0.01p
Mn87 n87 n86 0 0 NMOD W=10u L=1u
Mp87 n87 n86 vdd vdd PMOD W=20u L=1u
CL87 n87 0 0.01p
Mn88 n88 n87 0 0 NMOD W=10u L=1u
Mp88 n88 n87 vdd vdd PMOD W=20u L=1u
CL88 n88 0 0.01p
Mn89 n89 n88 0 0 NMOD W=10u L=1u
Mp89 n89 n88 vdd vdd PMOD W=20u L=1u
CL89 n89 0 0.01p
Mn90 n90 n89 0 0 NMOD W=10u L=1u
Mp90 n90 n89 vdd vdd PMOD W=20u L=1u
CL90 n90 0 0.01p
Mn91 n91 n90 0 0 NMOD W=10u L=1u
Mp91 n91 n90 vdd vdd PMOD W=20u L=1u
CL91 n91 0 0.01p
Mn92 n92 n91 0 0 NMOD W=10u L=1u
Mp92 n92 n91 vdd vdd PMOD W=20u L=1u
CL92 n92 0 0.01p
Mn93 n93 n92 0 0 NMOD W=10u L=1u
Mp93 n93 n92 vdd vdd PMOD W=20u L=1u
CL93 n93 0 0.01p
Mn94 n94 n93 0 0 NMOD W=10u L=1u
Mp94 n94 n93 vdd vdd PMOD W=20u L=1u
CL94 n94 0 0.01p
Mn95 n95 n94 0 0 NMOD W=10u L=1u
Mp95 n95 n94 vdd vdd PMOD W=20u L=1u
CL95 n95 0 0.01p
Mn96 n96 n95 0 0 NMOD W=10u L=1u
Mp96 n96 n95 vdd vdd PMOD W=20u L=1u
CL96 n96 0 0.01p
Mn97 n97 n96 0 0 NMOD W=10u L=1u
Mp97 n97 n96 vdd vdd PMOD W=20u L=1u
CL97 n97 0 0.01p
Mn98 n98 n97 0 0 NMOD W=10u L=1u
Mp98 n98 n97 vdd vdd PMOD W=20u L=1u
CL98 n98 0 0.01p
Mn99 n99 n98 0 0 NMOD W=10u L=1u
Mp99 n99 n98 vdd vdd PMOD W=20u L=1u
CL99 n99 0 0.01p
Mn100 n100 n99 0 0 NMOD W=10u L=1u
Mp100 n100 n99 vdd vdd PMOD W=20u L=1u
CL100 n100 0 0.01p
Mn101 n101 n100 0 0 NMOD W=10u L=1u
Mp101 n101 n100 vdd vdd PMOD W=20u L=1u
CL101 n101 0 0.01p
Mn102 n102 n101 0 0 NMOD W=10u L=1u
Mp102 n102 n101 vdd vdd PMOD W=20u L=1u
CL102 n102 0 0.01p
Mn103 n103 n102 0 0 NMOD W=10u L=1u
Mp103 n103 n102 vdd vdd PMOD W=20u L=1u
CL103 n103 0 0.01p
Mn104 n104 n103 0 0 NMOD W=10u L=1u
Mp104 n104 n103 vdd vdd PMOD W=20u L=1u
CL104 n104 0 0.01p
Mn105 n105 n104 0 0 NMOD W=10u L=1u
Mp105 n105 n104 vdd vdd PMOD W=20u L=1u
CL105 n105 0 0.01p
Mn106 n106 n105 0 0 NMOD W=10u L=1u
Mp106 n106 n105 vdd vdd PMOD W=20u L=1u
CL106 n106 0 0.01p
Mn107 n107 n106 0 0 NMOD W=10u L=1u
Mp107 n107 n106 vdd vdd PMOD W=20u L=1u
CL107 n107 0 0.01p
Mn108 n108 n107 0 0 NMOD W=10u L=1u
Mp108 n108 n107 vdd vdd PMOD W=20u L=1u
CL108 n108 0 0.01p
Mn109 n109 n108 0 0 NMOD W=10u L=1u
Mp109 n109 n108 vdd vdd PMOD W=20u L=1u
CL109 n109 0 0.01p
Mn110 n110 n109 0 0 NMOD W=10u L=1u
Mp110 n110 n109 vdd vdd PMOD W=20u L=1u
CL110 n110 0 0.01p
Mn111 n111 n110 0 0 NMOD W=10u L=1u
Mp111 n111 n110 vdd vdd PMOD W=20u L=1u
CL111 n111 0 0.01p
Mn112 n112 n111 0 0 NMOD W=10u L=1u
Mp112 n112 n111 vdd vdd PMOD W=20u L=1u
CL112 n112 0 0.01p
Mn113 n113 n112 0 0 NMOD W=10u L=1u
Mp113 n113 n112 vdd vdd PMOD W=20u L=1u
CL113 n113 0 0.01p
Mn114 n114 n113 0 0 NMOD W=10u L=1u
Mp114 n114 n113 vdd vdd PMOD W=20u L=1u
CL114 n114 0 0.01p
Mn115 n115 n114 0 0 NMOD W=10u L=1u
Mp115 n115 n114 vdd vdd PMOD W=20u L=1u
CL115 n115 0 0.01p
Mn116 n116 n115 0 0 NMOD W=10u L=1u
Mp116 n116 n115 vdd vdd PMOD W=20u L=1u
CL116 n116 0 0.01p
Mn117 n117 n116 0 0 NMOD W=10u L=1u
Mp117 n117 n116 vdd vdd PMOD W=20u L=1u
CL117 n117 0 0.01p
Mn118 n118 n117 0 0 NMOD W=10u L=1u
Mp118 n118 n117 vdd vdd PMOD W=20u L=1u
CL118 n118 0 0.01p
Mn119 n119 n118 0 0 NMOD W=10u L=1u
Mp119 n119 n118 vdd vdd PMOD W=20u L=1u
CL119 n119 0 0.01p
Mn120 n120 n119 0 0 NMOD W=10u L=1u
Mp120 n120 n119 vdd vdd PMOD W=20u L=1u
CL120 n120 0 0.01p
Mn121 n121 n120 0 0 NMOD W=10u L=1u
Mp121 n121 n120 vdd vdd PMOD W=20u L=1u
CL121 n121 0 0.01p
Mn122 n122 n121 0 0 NMOD W=10u L=1u
Mp122 n122 n121 vdd vdd PMOD W=20u L=1u
CL122 n122 0 0.01p
Mn123 n123 n122 0 0 NMOD W=10u L=1u
Mp123 n123 n122 vdd vdd PMOD W=20u L=1u
CL123 n123 0 0.01p
Mn124 n124 n123 0 0 NMOD W=10u L=1u
Mp124 n124 n123 vdd vdd PMOD W=20u L=1u
CL124 n124 0 0.01p
Mn125 n125 n124 0 0 NMOD W=10u L=1u
Mp125 n125 n124 vdd vdd PMOD W=20u L=1u
CL125 n125 0 0.01p
Mn126 n126 n125 0 0 NMOD W=10u L=1u
Mp126 n126 n125 vdd vdd PMOD W=20u L=1u
CL126 n126 0 0.01p
Mn127 n127 n126 0 0 NMOD W=10u L=1u
Mp127 n127 n126 vdd vdd PMOD W=20u L=1u
CL127 n127 0 0.01p
Mn128 n128 n127 0 0 NMOD W=10u L=1u
Mp128 n128 n127 vdd vdd PMOD W=20u L=1u
CL128 n128 0 0.01p
Mn129 n129 n128 0 0 NMOD W=10u L=1u
Mp129 n129 n128 vdd vdd PMOD W=20u L=1u
CL129 n129 0 0.01p
Mn130 n130 n129 0 0 NMOD W=10u L=1u
Mp130 n130 n129 vdd vdd PMOD W=20u L=1u
CL130 n130 0 0.01p
Mn131 n131 n130 0 0 NMOD W=10u L=1u
Mp131 n131 n130 vdd vdd PMOD W=20u L=1u
CL131 n131 0 0.01p
Mn132 n132 n131 0 0 NMOD W=10u L=1u
Mp132 n132 n131 vdd vdd PMOD W=20u L=1u
CL132 n132 0 0.01p
Mn133 n133 n132 0 0 NMOD W=10u L=1u
Mp133 n133 n132 vdd vdd PMOD W=20u L=1u
CL133 n133 0 0.01p
Mn134 n134 n133 0 0 NMOD W=10u L=1u
Mp134 n134 n133 vdd vdd PMOD W=20u L=1u
CL134 n134 0 0.01p
Mn135 n135 n134 0 0 NMOD W=10u L=1u
Mp135 n135 n134 vdd vdd PMOD W=20u L=1u
CL135 n135 0 0.01p
Mn136 n136 n135 0 0 NMOD W=10u L=1u
Mp136 n136 n135 vdd vdd PMOD W=20u L=1u
CL136 n136 0 0.01p
Mn137 n137 n136 0 0 NMOD W=10u L=1u
Mp137 n137 n136 vdd vdd PMOD W=20u L=1u
CL137 n137 0 0.01p
Mn138 n138 n137 0 0 NMOD W=10u L=1u
Mp138 n138 n137 vdd vdd PMOD W=20u L=1u
CL138 n138 0 0.01p
Mn139 n139 n138 0 0 NMOD W=10u L=1u
Mp139 n139 n138 vdd vdd PMOD W=20u L=1u
CL139 n139 0 0.01p
Mn140 n140 n139 0 0 NMOD W=10u L=1u
Mp140 n140 n139 vdd vdd PMOD W=20u L=1u
CL140 n140 0 0.01p
Mn141 n141 n140 0 0 NMOD W=10u L=1u
Mp141 n141 n140 vdd vdd PMOD W=20u L=1u
CL141 n141 0 0.01p
Mn142 n142 n141 0 0 NMOD W=10u L=1u
Mp142 n142 n141 vdd vdd PMOD W=20u L=1u
CL142 n142 0 0.01p
Mn143 n143 n142 0 0 NMOD W=10u L=1u
Mp143 n143 n142 vdd vdd PMOD W=20u L=1u
CL143 n143 0 0.01p
Mn144 n144 n143 0 0 NMOD W=10u L=1u
Mp144 n144 n143 vdd vdd PMOD W=20u L=1u
CL144 n144 0 0.01p
Mn145 n145 n144 0 0 NMOD W=10u L=1u
Mp145 n145 n144 vdd vdd PMOD W=20u L=1u
CL145 n145 0 0.01p
Mn146 n146 n145 0 0 NMOD W=10u L=1u
Mp146 n146 n145 vdd vdd PMOD W=20u L=1u
CL146 n146 0 0.01p
Mn147 n147 n146 0 0 NMOD W=10u L=1u
Mp147 n147 n146 vdd vdd PMOD W=20u L=1u
CL147 n147 0 0.01p
Mn148 n148 n147 0 0 NMOD W=10u L=1u
Mp148 n148 n147 vdd vdd PMOD W=20u L=1u
CL148 n148 0 0.01p
Mn149 n149 n148 0 0 NMOD W=10u L=1u
Mp149 n149 n148 vdd vdd PMOD W=20u L=1u
CL149 n149 0 0.01p
Mn150 n150 n149 0 0 NMOD W=10u L=1u
Mp150 n150 n149 vdd vdd PMOD W=20u L=1u
CL150 n150 0 0.01p
Mn151 n151 n150 0 0 NMOD W=10u L=1u
Mp151 n151 n150 vdd vdd PMOD W=20u L=1u
CL151 n151 0 0.01p
Mn152 n152 n151 0 0 NMOD W=10u L=1u
Mp152 n152 n151 vdd vdd PMOD W=20u L=1u
CL152 n152 0 0.01p
Mn153 n153 n152 0 0 NMOD W=10u L=1u
Mp153 n153 n152 vdd vdd PMOD W=20u L=1u
CL153 n153 0 0.01p
Mn154 n154 n153 0 0 NMOD W=10u L=1u
Mp154 n154 n153 vdd vdd PMOD W=20u L=1u
CL154 n154 0 0.01p
Mn155 n155 n154 0 0 NMOD W=10u L=1u
Mp155 n155 n154 vdd vdd PMOD W=20u L=1u
CL155 n155 0 0.01p
Mn156 n156 n155 0 0 NMOD W=10u L=1u
Mp156 n156 n155 vdd vdd PMOD W=20u L=1u
CL156 n156 0 0.01p
Mn157 n157 n156 0 0 NMOD W=10u L=1u
Mp157 n157 n156 vdd vdd PMOD W=20u L=1u
CL157 n157 0 0.01p
Mn158 n158 n157 0 0 NMOD W=10u L=1u
Mp158 n158 n157 vdd vdd PMOD W=20u L=1u
CL158 n158 0 0.01p
Mn159 n159 n158 0 0 NMOD W=10u L=1u
Mp159 n159 n158 vdd vdd PMOD W=20u L=1u
CL159 n159 0 0.01p
Mn160 n160 n159 0 0 NMOD W=10u L=1u
Mp160 n160 n159 vdd vdd PMOD W=20u L=1u
CL160 n160 0 0.01p
Mn161 n161 n160 0 0 NMOD W=10u L=1u
Mp161 n161 n160 vdd vdd PMOD W=20u L=1u
CL161 n161 0 0.01p
Mn162 n162 n161 0 0 NMOD W=10u L=1u
Mp162 n162 n161 vdd vdd PMOD W=20u L=1u
CL162 n162 0 0.01p
Mn163 n163 n162 0 0 NMOD W=10u L=1u
Mp163 n163 n162 vdd vdd PMOD W=20u L=1u
CL163 n163 0 0.01p
Mn164 n164 n163 0 0 NMOD W=10u L=1u
Mp164 n164 n163 vdd vdd PMOD W=20u L=1u
CL164 n164 0 0.01p
Mn165 n165 n164 0 0 NMOD W=10u L=1u
Mp165 n165 n164 vdd vdd PMOD W=20u L=1u
CL165 n165 0 0.01p
Mn166 n166 n165 0 0 NMOD W=10u L=1u
Mp166 n166 n165 vdd vdd PMOD W=20u L=1u
CL166 n166 0 0.01p
Mn167 n167 n166 0 0 NMOD W=10u L=1u
Mp167 n167 n166 vdd vdd PMOD W=20u L=1u
CL167 n167 0 0.01p
Mn168 n168 n167 0 0 NMOD W=10u L=1u
Mp168 n168 n167 vdd vdd PMOD W=20u L=1u
CL168 n168 0 0.01p
Mn169 n169 n168 0 0 NMOD W=10u L=1u
Mp169 n169 n168 vdd vdd PMOD W=20u L=1u
CL169 n169 0 0.01p
Mn170 n170 n169 0 0 NMOD W=10u L=1u
Mp170 n170 n169 vdd vdd PMOD W=20u L=1u
CL170 n170 0 0.01p
Mn171 n171 n170 0 0 NMOD W=10u L=1u
Mp171 n171 n170 vdd vdd PMOD W=20u L=1u
CL171 n171 0 0.01p
Mn172 n172 n171 0 0 NMOD W=10u L=1u
Mp172 n172 n171 vdd vdd PMOD W=20u L=1u
CL172 n172 0 0.01p
Mn173 n173 n172 0 0 NMOD W=10u L=1u
Mp173 n173 n172 vdd vdd PMOD W=20u L=1u
CL173 n173 0 0.01p
Mn174 n174 n173 0 0 NMOD W=10u L=1u
Mp174 n174 n173 vdd vdd PMOD W=20u L=1u
CL174 n174 0 0.01p
Mn175 n175 n174 0 0 NMOD W=10u L=1u
Mp175 n175 n174 vdd vdd PMOD W=20u L=1u
CL175 n175 0 0.01p
Mn176 n176 n175 0 0 NMOD W=10u L=1u
Mp176 n176 n175 vdd vdd PMOD W=20u L=1u
CL176 n176 0 0.01p
Mn177 n177 n176 0 0 NMOD W=10u L=1u
Mp177 n177 n176 vdd vdd PMOD W=20u L=1u
CL177 n177 0 0.01p
Mn178 n178 n177 0 0 NMOD W=10u L=1u
Mp178 n178 n177 vdd vdd PMOD W=20u L=1u
CL178 n178 0 0.01p
Mn179 n179 n178 0 0 NMOD W=10u L=1u
Mp179 n179 n178 vdd vdd PMOD W=20u L=1u
CL179 n179 0 0.01p
Mn180 n180 n179 0 0 NMOD W=10u L=1u
Mp180 n180 n179 vdd vdd PMOD W=20u L=1u
CL180 n180 0 0.01p
Mn181 n181 n180 0 0 NMOD W=10u L=1u
Mp181 n181 n180 vdd vdd PMOD W=20u L=1u
CL181 n181 0 0.01p
Mn182 n182 n181 0 0 NMOD W=10u L=1u
Mp182 n182 n181 vdd vdd PMOD W=20u L=1u
CL182 n182 0 0.01p
Mn183 n183 n182 0 0 NMOD W=10u L=1u
Mp183 n183 n182 vdd vdd PMOD W=20u L=1u
CL183 n183 0 0.01p
Mn184 n184 n183 0 0 NMOD W=10u L=1u
Mp184 n184 n183 vdd vdd PMOD W=20u L=1u
CL184 n184 0 0.01p
Mn185 n185 n184 0 0 NMOD W=10u L=1u
Mp185 n185 n184 vdd vdd PMOD W=20u L=1u
CL185 n185 0 0.01p
Mn186 n186 n185 0 0 NMOD W=10u L=1u
Mp186 n186 n185 vdd vdd PMOD W=20u L=1u
CL186 n186 0 0.01p
Mn187 n187 n186 0 0 NMOD W=10u L=1u
Mp187 n187 n186 vdd vdd PMOD W=20u L=1u
CL187 n187 0 0.01p
Mn188 n188 n187 0 0 NMOD W=10u L=1u
Mp188 n188 n187 vdd vdd PMOD W=20u L=1u
CL188 n188 0 0.01p
Mn189 n189 n188 0 0 NMOD W=10u L=1u
Mp189 n189 n188 vdd vdd PMOD W=20u L=1u
CL189 n189 0 0.01p
Mn190 n190 n189 0 0 NMOD W=10u L=1u
Mp190 n190 n189 vdd vdd PMOD W=20u L=1u
CL190 n190 0 0.01p
Mn191 n191 n190 0 0 NMOD W=10u L=1u
Mp191 n191 n190 vdd vdd PMOD W=20u L=1u
CL191 n191 0 0.01p
Mn192 n192 n191 0 0 NMOD W=10u L=1u
Mp192 n192 n191 vdd vdd PMOD W=20u L=1u
CL192 n192 0 0.01p
Mn193 n193 n192 0 0 NMOD W=10u L=1u
Mp193 n193 n192 vdd vdd PMOD W=20u L=1u
CL193 n193 0 0.01p
Mn194 n194 n193 0 0 NMOD W=10u L=1u
Mp194 n194 n193 vdd vdd PMOD W=20u L=1u
CL194 n194 0 0.01p
Mn195 n195 n194 0 0 NMOD W=10u L=1u
Mp195 n195 n194 vdd vdd PMOD W=20u L=1u
CL195 n195 0 0.01p
Mn196 n196 n195 0 0 NMOD W=10u L=1u
Mp196 n196 n195 vdd vdd PMOD W=20u L=1u
CL196 n196 0 0.01p
Mn197 n197 n196 0 0 NMOD W=10u L=1u
Mp197 n197 n196 vdd vdd PMOD W=20u L=1u
CL197 n197 0 0.01p
Mn198 n198 n197 0 0 NMOD W=10u L=1u
Mp198 n198 n197 vdd vdd PMOD W=20u L=1u
CL198 n198 0 0.01p
Mn199 n199 n198 0 0 NMOD W=10u L=1u
Mp199 n199 n198 vdd vdd PMOD W=20u L=1u
CL199 n199 0 0.01p
Mn200 n200 n199 0 0 NMOD W=10u L=1u
Mp200 n200 n199 vdd vdd PMOD W=20u L=1u
CL200 n200 0 0.01p
Mn201 n201 n200 0 0 NMOD W=10u L=1u
Mp201 n201 n200 vdd vdd PMOD W=20u L=1u
CL201 n201 0 0.01p
Mn202 n202 n201 0 0 NMOD W=10u L=1u
Mp202 n202 n201 vdd vdd PMOD W=20u L=1u
CL202 n202 0 0.01p
Mn203 n203 n202 0 0 NMOD W=10u L=1u
Mp203 n203 n202 vdd vdd PMOD W=20u L=1u
CL203 n203 0 0.01p
Mn204 n204 n203 0 0 NMOD W=10u L=1u
Mp204 n204 n203 vdd vdd PMOD W=20u L=1u
CL204 n204 0 0.01p
Mn205 n205 n204 0 0 NMOD W=10u L=1u
Mp205 n205 n204 vdd vdd PMOD W=20u L=1u
CL205 n205 0 0.01p
Mn206 n206 n205 0 0 NMOD W=10u L=1u
Mp206 n206 n205 vdd vdd PMOD W=20u L=1u
CL206 n206 0 0.01p
Mn207 n207 n206 0 0 NMOD W=10u L=1u
Mp207 n207 n206 vdd vdd PMOD W=20u L=1u
CL207 n207 0 0.01p
Mn208 n208 n207 0 0 NMOD W=10u L=1u
Mp208 n208 n207 vdd vdd PMOD W=20u L=1u
CL208 n208 0 0.01p
Mn209 n209 n208 0 0 NMOD W=10u L=1u
Mp209 n209 n208 vdd vdd PMOD W=20u L=1u
CL209 n209 0 0.01p
Mn210 n210 n209 0 0 NMOD W=10u L=1u
Mp210 n210 n209 vdd vdd PMOD W=20u L=1u
CL210 n210 0 0.01p
Mn211 n211 n210 0 0 NMOD W=10u L=1u
Mp211 n211 n210 vdd vdd PMOD W=20u L=1u
CL211 n211 0 0.01p
Mn212 n212 n211 0 0 NMOD W=10u L=1u
Mp212 n212 n211 vdd vdd PMOD W=20u L=1u
CL212 n212 0 0.01p
Mn213 n213 n212 0 0 NMOD W=10u L=1u
Mp213 n213 n212 vdd vdd PMOD W=20u L=1u
CL213 n213 0 0.01p
Mn214 n214 n213 0 0 NMOD W=10u L=1u
Mp214 n214 n213 vdd vdd PMOD W=20u L=1u
CL214 n214 0 0.01p
Mn215 n215 n214 0 0 NMOD W=10u L=1u
Mp215 n215 n214 vdd vdd PMOD W=20u L=1u
CL215 n215 0 0.01p
Mn216 n216 n215 0 0 NMOD W=10u L=1u
Mp216 n216 n215 vdd vdd PMOD W=20u L=1u
CL216 n216 0 0.01p
Mn217 n217 n216 0 0 NMOD W=10u L=1u
Mp217 n217 n216 vdd vdd PMOD W=20u L=1u
CL217 n217 0 0.01p
Mn218 n218 n217 0 0 NMOD W=10u L=1u
Mp218 n218 n217 vdd vdd PMOD W=20u L=1u
CL218 n218 0 0.01p
Mn219 n219 n218 0 0 NMOD W=10u L=1u
Mp219 n219 n218 vdd vdd PMOD W=20u L=1u
CL219 n219 0 0.01p
Mn220 n220 n219 0 0 NMOD W=10u L=1u
Mp220 n220 n219 vdd vdd PMOD W=20u L=1u
CL220 n220 0 0.01p
Mn221 n221 n220 0 0 NMOD W=10u L=1u
Mp221 n221 n220 vdd vdd PMOD W=20u L=1u
CL221 n221 0 0.01p
Mn222 n222 n221 0 0 NMOD W=10u L=1u
Mp222 n222 n221 vdd vdd PMOD W=20u L=1u
CL222 n222 0 0.01p
Mn223 n223 n222 0 0 NMOD W=10u L=1u
Mp223 n223 n222 vdd vdd PMOD W=20u L=1u
CL223 n223 0 0.01p
Mn224 n224 n223 0 0 NMOD W=10u L=1u
Mp224 n224 n223 vdd vdd PMOD W=20u L=1u
CL224 n224 0 0.01p
Mn225 n225 n224 0 0 NMOD W=10u L=1u
Mp225 n225 n224 vdd vdd PMOD W=20u L=1u
CL225 n225 0 0.01p
Mn226 n226 n225 0 0 NMOD W=10u L=1u
Mp226 n226 n225 vdd vdd PMOD W=20u L=1u
CL226 n226 0 0.01p
Mn227 n227 n226 0 0 NMOD W=10u L=1u
Mp227 n227 n226 vdd vdd PMOD W=20u L=1u
CL227 n227 0 0.01p
Mn228 n228 n227 0 0 NMOD W=10u L=1u
Mp228 n228 n227 vdd vdd PMOD W=20u L=1u
CL228 n228 0 0.01p
Mn229 n229 n228 0 0 NMOD W=10u L=1u
Mp229 n229 n228 vdd vdd PMOD W=20u L=1u
CL229 n229 0 0.01p
Mn230 n230 n229 0 0 NMOD W=10u L=1u
Mp230 n230 n229 vdd vdd PMOD W=20u L=1u
CL230 n230 0 0.01p
Mn231 n231 n230 0 0 NMOD W=10u L=1u
Mp231 n231 n230 vdd vdd PMOD W=20u L=1u
CL231 n231 0 0.01p
Mn232 n232 n231 0 0 NMOD W=10u L=1u
Mp232 n232 n231 vdd vdd PMOD W=20u L=1u
CL232 n232 0 0.01p
Mn233 n233 n232 0 0 NMOD W=10u L=1u
Mp233 n233 n232 vdd vdd PMOD W=20u L=1u
CL233 n233 0 0.01p
Mn234 n234 n233 0 0 NMOD W=10u L=1u
Mp234 n234 n233 vdd vdd PMOD W=20u L=1u
CL234 n234 0 0.01p
Mn235 n235 n234 0 0 NMOD W=10u L=1u
Mp235 n235 n234 vdd vdd PMOD W=20u L=1u
CL235 n235 0 0.01p
Mn236 n236 n235 0 0 NMOD W=10u L=1u
Mp236 n236 n235 vdd vdd PMOD W=20u L=1u
CL236 n236 0 0.01p
Mn237 n237 n236 0 0 NMOD W=10u L=1u
Mp237 n237 n236 vdd vdd PMOD W=20u L=1u
CL237 n237 0 0.01p
Mn238 n238 n237 0 0 NMOD W=10u L=1u
Mp238 n238 n237 vdd vdd PMOD W=20u L=1u
CL238 n238 0 0.01p
Mn239 n239 n238 0 0 NMOD W=10u L=1u
Mp239 n239 n238 vdd vdd PMOD W=20u L=1u
CL239 n239 0 0.01p
Mn240 n240 n239 0 0 NMOD W=10u L=1u
Mp240 n240 n239 vdd vdd PMOD W=20u L=1u
CL240 n240 0 0.01p
Mn241 n241 n240 0 0 NMOD W=10u L=1u
Mp241 n241 n240 vdd vdd PMOD W=20u L=1u
CL241 n241 0 0.01p
Mn242 n242 n241 0 0 NMOD W=10u L=1u
Mp242 n242 n241 vdd vdd PMOD W=20u L=1u
CL242 n242 0 0.01p
Mn243 n243 n242 0 0 NMOD W=10u L=1u
Mp243 n243 n242 vdd vdd PMOD W=20u L=1u
CL243 n243 0 0.01p
Mn244 n244 n243 0 0 NMOD W=10u L=1u
Mp244 n244 n243 vdd vdd PMOD W=20u L=1u
CL244 n244 0 0.01p
Mn245 n245 n244 0 0 NMOD W=10u L=1u
Mp245 n245 n244 vdd vdd PMOD W=20u L=1u
CL245 n245 0 0.01p
Mn246 n246 n245 0 0 NMOD W=10u L=1u
Mp246 n246 n245 vdd vdd PMOD W=20u L=1u
CL246 n246 0 0.01p
Mn247 n247 n246 0 0 NMOD W=10u L=1u
Mp247 n247 n246 vdd vdd PMOD W=20u L=1u
CL247 n247 0 0.01p
Mn248 n248 n247 0 0 NMOD W=10u L=1u
Mp248 n248 n247 vdd vdd PMOD W=20u L=1u
CL248 n248 0 0.01p
Mn249 n249 n248 0 0 NMOD W=10u L=1u
Mp249 n249 n248 vdd vdd PMOD W=20u L=1u
CL249 n249 0 0.01p
Mn250 n250 n249 0 0 NMOD W=10u L=1u
Mp250 n250 n249 vdd vdd PMOD W=20u L=1u
CL250 n250 0 0.01p
Mn251 n251 n250 0 0 NMOD W=10u L=1u
Mp251 n251 n250 vdd vdd PMOD W=20u L=1u
CL251 n251 0 0.01p
Mn252 n252 n251 0 0 NMOD W=10u L=1u
Mp252 n252 n251 vdd vdd PMOD W=20u L=1u
CL252 n252 0 0.01p
Mn253 n253 n252 0 0 NMOD W=10u L=1u
Mp253 n253 n252 vdd vdd PMOD W=20u L=1u
CL253 n253 0 0.01p
Mn254 n254 n253 0 0 NMOD W=10u L=1u
Mp254 n254 n253 vdd vdd PMOD W=20u L=1u
CL254 n254 0 0.01p
Mn255 n255 n254 0 0 NMOD W=10u L=1u
Mp255 n255 n254 vdd vdd PMOD W=20u L=1u
CL255 n255 0 0.01p
Mn256 n256 n255 0 0 NMOD W=10u L=1u
Mp256 n256 n255 vdd vdd PMOD W=20u L=1u
CL256 n256 0 0.01p
Mn257 n257 n256 0 0 NMOD W=10u L=1u
Mp257 n257 n256 vdd vdd PMOD W=20u L=1u
CL257 n257 0 0.01p
Mn258 n258 n257 0 0 NMOD W=10u L=1u
Mp258 n258 n257 vdd vdd PMOD W=20u L=1u
CL258 n258 0 0.01p
Mn259 n259 n258 0 0 NMOD W=10u L=1u
Mp259 n259 n258 vdd vdd PMOD W=20u L=1u
CL259 n259 0 0.01p
Mn260 n260 n259 0 0 NMOD W=10u L=1u
Mp260 n260 n259 vdd vdd PMOD W=20u L=1u
CL260 n260 0 0.01p
Mn261 n261 n260 0 0 NMOD W=10u L=1u
Mp261 n261 n260 vdd vdd PMOD W=20u L=1u
CL261 n261 0 0.01p
Mn262 n262 n261 0 0 NMOD W=10u L=1u
Mp262 n262 n261 vdd vdd PMOD W=20u L=1u
CL262 n262 0 0.01p
Mn263 n263 n262 0 0 NMOD W=10u L=1u
Mp263 n263 n262 vdd vdd PMOD W=20u L=1u
CL263 n263 0 0.01p
Mn264 n264 n263 0 0 NMOD W=10u L=1u
Mp264 n264 n263 vdd vdd PMOD W=20u L=1u
CL264 n264 0 0.01p
Mn265 n265 n264 0 0 NMOD W=10u L=1u
Mp265 n265 n264 vdd vdd PMOD W=20u L=1u
CL265 n265 0 0.01p
Mn266 n266 n265 0 0 NMOD W=10u L=1u
Mp266 n266 n265 vdd vdd PMOD W=20u L=1u
CL266 n266 0 0.01p
Mn267 n267 n266 0 0 NMOD W=10u L=1u
Mp267 n267 n266 vdd vdd PMOD W=20u L=1u
CL267 n267 0 0.01p
Mn268 n268 n267 0 0 NMOD W=10u L=1u
Mp268 n268 n267 vdd vdd PMOD W=20u L=1u
CL268 n268 0 0.01p
Mn269 n269 n268 0 0 NMOD W=10u L=1u
Mp269 n269 n268 vdd vdd PMOD W=20u L=1u
CL269 n269 0 0.01p
Mn270 n270 n269 0 0 NMOD W=10u L=1u
Mp270 n270 n269 vdd vdd PMOD W=20u L=1u
CL270 n270 0 0.01p
Mn271 n271 n270 0 0 NMOD W=10u L=1u
Mp271 n271 n270 vdd vdd PMOD W=20u L=1u
CL271 n271 0 0.01p
Mn272 n272 n271 0 0 NMOD W=10u L=1u
Mp272 n272 n271 vdd vdd PMOD W=20u L=1u
CL272 n272 0 0.01p
Mn273 n273 n272 0 0 NMOD W=10u L=1u
Mp273 n273 n272 vdd vdd PMOD W=20u L=1u
CL273 n273 0 0.01p
Mn274 n274 n273 0 0 NMOD W=10u L=1u
Mp274 n274 n273 vdd vdd PMOD W=20u L=1u
CL274 n274 0 0.01p
Mn275 n275 n274 0 0 NMOD W=10u L=1u
Mp275 n275 n274 vdd vdd PMOD W=20u L=1u
CL275 n275 0 0.01p
Mn276 n276 n275 0 0 NMOD W=10u L=1u
Mp276 n276 n275 vdd vdd PMOD W=20u L=1u
CL276 n276 0 0.01p
Mn277 n277 n276 0 0 NMOD W=10u L=1u
Mp277 n277 n276 vdd vdd PMOD W=20u L=1u
CL277 n277 0 0.01p
Mn278 n278 n277 0 0 NMOD W=10u L=1u
Mp278 n278 n277 vdd vdd PMOD W=20u L=1u
CL278 n278 0 0.01p
Mn279 n279 n278 0 0 NMOD W=10u L=1u
Mp279 n279 n278 vdd vdd PMOD W=20u L=1u
CL279 n279 0 0.01p
Mn280 n280 n279 0 0 NMOD W=10u L=1u
Mp280 n280 n279 vdd vdd PMOD W=20u L=1u
CL280 n280 0 0.01p
Mn281 n281 n280 0 0 NMOD W=10u L=1u
Mp281 n281 n280 vdd vdd PMOD W=20u L=1u
CL281 n281 0 0.01p
Mn282 n282 n281 0 0 NMOD W=10u L=1u
Mp282 n282 n281 vdd vdd PMOD W=20u L=1u
CL282 n282 0 0.01p
Mn283 n283 n282 0 0 NMOD W=10u L=1u
Mp283 n283 n282 vdd vdd PMOD W=20u L=1u
CL283 n283 0 0.01p
Mn284 n284 n283 0 0 NMOD W=10u L=1u
Mp284 n284 n283 vdd vdd PMOD W=20u L=1u
CL284 n284 0 0.01p
Mn285 n285 n284 0 0 NMOD W=10u L=1u
Mp285 n285 n284 vdd vdd PMOD W=20u L=1u
CL285 n285 0 0.01p
Mn286 n286 n285 0 0 NMOD W=10u L=1u
Mp286 n286 n285 vdd vdd PMOD W=20u L=1u
CL286 n286 0 0.01p
Mn287 n287 n286 0 0 NMOD W=10u L=1u
Mp287 n287 n286 vdd vdd PMOD W=20u L=1u
CL287 n287 0 0.01p
Mn288 n288 n287 0 0 NMOD W=10u L=1u
Mp288 n288 n287 vdd vdd PMOD W=20u L=1u
CL288 n288 0 0.01p
Mn289 n289 n288 0 0 NMOD W=10u L=1u
Mp289 n289 n288 vdd vdd PMOD W=20u L=1u
CL289 n289 0 0.01p
Mn290 n290 n289 0 0 NMOD W=10u L=1u
Mp290 n290 n289 vdd vdd PMOD W=20u L=1u
CL290 n290 0 0.01p
Mn291 n291 n290 0 0 NMOD W=10u L=1u
Mp291 n291 n290 vdd vdd PMOD W=20u L=1u
CL291 n291 0 0.01p
Mn292 n292 n291 0 0 NMOD W=10u L=1u
Mp292 n292 n291 vdd vdd PMOD W=20u L=1u
CL292 n292 0 0.01p
Mn293 n293 n292 0 0 NMOD W=10u L=1u
Mp293 n293 n292 vdd vdd PMOD W=20u L=1u
CL293 n293 0 0.01p
Mn294 n294 n293 0 0 NMOD W=10u L=1u
Mp294 n294 n293 vdd vdd PMOD W=20u L=1u
CL294 n294 0 0.01p
Mn295 n295 n294 0 0 NMOD W=10u L=1u
Mp295 n295 n294 vdd vdd PMOD W=20u L=1u
CL295 n295 0 0.01p
Mn296 n296 n295 0 0 NMOD W=10u L=1u
Mp296 n296 n295 vdd vdd PMOD W=20u L=1u
CL296 n296 0 0.01p
Mn297 n297 n296 0 0 NMOD W=10u L=1u
Mp297 n297 n296 vdd vdd PMOD W=20u L=1u
CL297 n297 0 0.01p
Mn298 n298 n297 0 0 NMOD W=10u L=1u
Mp298 n298 n297 vdd vdd PMOD W=20u L=1u
CL298 n298 0 0.01p
Mn299 n299 n298 0 0 NMOD W=10u L=1u
Mp299 n299 n298 vdd vdd PMOD W=20u L=1u
CL299 n299 0 0.01p
Mn300 n300 n299 0 0 NMOD W=10u L=1u
Mp300 n300 n299 vdd vdd PMOD W=20u L=1u
CL300 n300 0 0.01p
Mn301 n301 n300 0 0 NMOD W=10u L=1u
Mp301 n301 n300 vdd vdd PMOD W=20u L=1u
CL301 n301 0 0.01p
Mn302 n302 n301 0 0 NMOD W=10u L=1u
Mp302 n302 n301 vdd vdd PMOD W=20u L=1u
CL302 n302 0 0.01p
Mn303 n303 n302 0 0 NMOD W=10u L=1u
Mp303 n303 n302 vdd vdd PMOD W=20u L=1u
CL303 n303 0 0.01p
Mn304 n304 n303 0 0 NMOD W=10u L=1u
Mp304 n304 n303 vdd vdd PMOD W=20u L=1u
CL304 n304 0 0.01p
Mn305 n305 n304 0 0 NMOD W=10u L=1u
Mp305 n305 n304 vdd vdd PMOD W=20u L=1u
CL305 n305 0 0.01p
Mn306 n306 n305 0 0 NMOD W=10u L=1u
Mp306 n306 n305 vdd vdd PMOD W=20u L=1u
CL306 n306 0 0.01p
Mn307 n307 n306 0 0 NMOD W=10u L=1u
Mp307 n307 n306 vdd vdd PMOD W=20u L=1u
CL307 n307 0 0.01p
Mn308 n308 n307 0 0 NMOD W=10u L=1u
Mp308 n308 n307 vdd vdd PMOD W=20u L=1u
CL308 n308 0 0.01p
Mn309 n309 n308 0 0 NMOD W=10u L=1u
Mp309 n309 n308 vdd vdd PMOD W=20u L=1u
CL309 n309 0 0.01p
Mn310 n310 n309 0 0 NMOD W=10u L=1u
Mp310 n310 n309 vdd vdd PMOD W=20u L=1u
CL310 n310 0 0.01p
Mn311 n311 n310 0 0 NMOD W=10u L=1u
Mp311 n311 n310 vdd vdd PMOD W=20u L=1u
CL311 n311 0 0.01p
Mn312 n312 n311 0 0 NMOD W=10u L=1u
Mp312 n312 n311 vdd vdd PMOD W=20u L=1u
CL312 n312 0 0.01p
Mn313 n313 n312 0 0 NMOD W=10u L=1u
Mp313 n313 n312 vdd vdd PMOD W=20u L=1u
CL313 n313 0 0.01p
Mn314 n314 n313 0 0 NMOD W=10u L=1u
Mp314 n314 n313 vdd vdd PMOD W=20u L=1u
CL314 n314 0 0.01p
Mn315 n315 n314 0 0 NMOD W=10u L=1u
Mp315 n315 n314 vdd vdd PMOD W=20u L=1u
CL315 n315 0 0.01p
Mn316 n316 n315 0 0 NMOD W=10u L=1u
Mp316 n316 n315 vdd vdd PMOD W=20u L=1u
CL316 n316 0 0.01p
Mn317 n317 n316 0 0 NMOD W=10u L=1u
Mp317 n317 n316 vdd vdd PMOD W=20u L=1u
CL317 n317 0 0.01p
Mn318 n318 n317 0 0 NMOD W=10u L=1u
Mp318 n318 n317 vdd vdd PMOD W=20u L=1u
CL318 n318 0 0.01p
Mn319 n319 n318 0 0 NMOD W=10u L=1u
Mp319 n319 n318 vdd vdd PMOD W=20u L=1u
CL319 n319 0 0.01p
Mn320 n320 n319 0 0 NMOD W=10u L=1u
Mp320 n320 n319 vdd vdd PMOD W=20u L=1u
CL320 n320 0 0.01p
Mn321 n321 n320 0 0 NMOD W=10u L=1u
Mp321 n321 n320 vdd vdd PMOD W=20u L=1u
CL321 n321 0 0.01p
Mn322 n322 n321 0 0 NMOD W=10u L=1u
Mp322 n322 n321 vdd vdd PMOD W=20u L=1u
CL322 n322 0 0.01p
Mn323 n323 n322 0 0 NMOD W=10u L=1u
Mp323 n323 n322 vdd vdd PMOD W=20u L=1u
CL323 n323 0 0.01p
Mn324 n324 n323 0 0 NMOD W=10u L=1u
Mp324 n324 n323 vdd vdd PMOD W=20u L=1u
CL324 n324 0 0.01p
Mn325 n325 n324 0 0 NMOD W=10u L=1u
Mp325 n325 n324 vdd vdd PMOD W=20u L=1u
CL325 n325 0 0.01p
Mn326 n326 n325 0 0 NMOD W=10u L=1u
Mp326 n326 n325 vdd vdd PMOD W=20u L=1u
CL326 n326 0 0.01p
Mn327 n327 n326 0 0 NMOD W=10u L=1u
Mp327 n327 n326 vdd vdd PMOD W=20u L=1u
CL327 n327 0 0.01p
Mn328 n328 n327 0 0 NMOD W=10u L=1u
Mp328 n328 n327 vdd vdd PMOD W=20u L=1u
CL328 n328 0 0.01p
Mn329 n329 n328 0 0 NMOD W=10u L=1u
Mp329 n329 n328 vdd vdd PMOD W=20u L=1u
CL329 n329 0 0.01p
Mn330 n330 n329 0 0 NMOD W=10u L=1u
Mp330 n330 n329 vdd vdd PMOD W=20u L=1u
CL330 n330 0 0.01p
Mn331 n331 n330 0 0 NMOD W=10u L=1u
Mp331 n331 n330 vdd vdd PMOD W=20u L=1u
CL331 n331 0 0.01p
Mn332 n332 n331 0 0 NMOD W=10u L=1u
Mp332 n332 n331 vdd vdd PMOD W=20u L=1u
CL332 n332 0 0.01p
Mn333 n333 n332 0 0 NMOD W=10u L=1u
Mp333 n333 n332 vdd vdd PMOD W=20u L=1u
CL333 n333 0 0.01p
Mn334 n334 n333 0 0 NMOD W=10u L=1u
Mp334 n334 n333 vdd vdd PMOD W=20u L=1u
CL334 n334 0 0.01p
Mn335 n335 n334 0 0 NMOD W=10u L=1u
Mp335 n335 n334 vdd vdd PMOD W=20u L=1u
CL335 n335 0 0.01p
Mn336 n336 n335 0 0 NMOD W=10u L=1u
Mp336 n336 n335 vdd vdd PMOD W=20u L=1u
CL336 n336 0 0.01p
Mn337 n337 n336 0 0 NMOD W=10u L=1u
Mp337 n337 n336 vdd vdd PMOD W=20u L=1u
CL337 n337 0 0.01p
Mn338 n338 n337 0 0 NMOD W=10u L=1u
Mp338 n338 n337 vdd vdd PMOD W=20u L=1u
CL338 n338 0 0.01p
Mn339 n339 n338 0 0 NMOD W=10u L=1u
Mp339 n339 n338 vdd vdd PMOD W=20u L=1u
CL339 n339 0 0.01p
Mn340 n340 n339 0 0 NMOD W=10u L=1u
Mp340 n340 n339 vdd vdd PMOD W=20u L=1u
CL340 n340 0 0.01p
Mn341 n341 n340 0 0 NMOD W=10u L=1u
Mp341 n341 n340 vdd vdd PMOD W=20u L=1u
CL341 n341 0 0.01p
Mn342 n342 n341 0 0 NMOD W=10u L=1u
Mp342 n342 n341 vdd vdd PMOD W=20u L=1u
CL342 n342 0 0.01p
Mn343 n343 n342 0 0 NMOD W=10u L=1u
Mp343 n343 n342 vdd vdd PMOD W=20u L=1u
CL343 n343 0 0.01p
Mn344 n344 n343 0 0 NMOD W=10u L=1u
Mp344 n344 n343 vdd vdd PMOD W=20u L=1u
CL344 n344 0 0.01p
Mn345 n345 n344 0 0 NMOD W=10u L=1u
Mp345 n345 n344 vdd vdd PMOD W=20u L=1u
CL345 n345 0 0.01p
Mn346 n346 n345 0 0 NMOD W=10u L=1u
Mp346 n346 n345 vdd vdd PMOD W=20u L=1u
CL346 n346 0 0.01p
Mn347 n347 n346 0 0 NMOD W=10u L=1u
Mp347 n347 n346 vdd vdd PMOD W=20u L=1u
CL347 n347 0 0.01p
Mn348 n348 n347 0 0 NMOD W=10u L=1u
Mp348 n348 n347 vdd vdd PMOD W=20u L=1u
CL348 n348 0 0.01p
Mn349 n349 n348 0 0 NMOD W=10u L=1u
Mp349 n349 n348 vdd vdd PMOD W=20u L=1u
CL349 n349 0 0.01p
Mn350 n350 n349 0 0 NMOD W=10u L=1u
Mp350 n350 n349 vdd vdd PMOD W=20u L=1u
CL350 n350 0 0.01p
Mn351 n351 n350 0 0 NMOD W=10u L=1u
Mp351 n351 n350 vdd vdd PMOD W=20u L=1u
CL351 n351 0 0.01p
Mn352 n352 n351 0 0 NMOD W=10u L=1u
Mp352 n352 n351 vdd vdd PMOD W=20u L=1u
CL352 n352 0 0.01p
Mn353 n353 n352 0 0 NMOD W=10u L=1u
Mp353 n353 n352 vdd vdd PMOD W=20u L=1u
CL353 n353 0 0.01p
Mn354 n354 n353 0 0 NMOD W=10u L=1u
Mp354 n354 n353 vdd vdd PMOD W=20u L=1u
CL354 n354 0 0.01p
Mn355 n355 n354 0 0 NMOD W=10u L=1u
Mp355 n355 n354 vdd vdd PMOD W=20u L=1u
CL355 n355 0 0.01p
Mn356 n356 n355 0 0 NMOD W=10u L=1u
Mp356 n356 n355 vdd vdd PMOD W=20u L=1u
CL356 n356 0 0.01p
Mn357 n357 n356 0 0 NMOD W=10u L=1u
Mp357 n357 n356 vdd vdd PMOD W=20u L=1u
CL357 n357 0 0.01p
Mn358 n358 n357 0 0 NMOD W=10u L=1u
Mp358 n358 n357 vdd vdd PMOD W=20u L=1u
CL358 n358 0 0.01p
Mn359 n359 n358 0 0 NMOD W=10u L=1u
Mp359 n359 n358 vdd vdd PMOD W=20u L=1u
CL359 n359 0 0.01p
Mn360 n360 n359 0 0 NMOD W=10u L=1u
Mp360 n360 n359 vdd vdd PMOD W=20u L=1u
CL360 n360 0 0.01p
Mn361 n361 n360 0 0 NMOD W=10u L=1u
Mp361 n361 n360 vdd vdd PMOD W=20u L=1u
CL361 n361 0 0.01p
Mn362 n362 n361 0 0 NMOD W=10u L=1u
Mp362 n362 n361 vdd vdd PMOD W=20u L=1u
CL362 n362 0 0.01p
Mn363 n363 n362 0 0 NMOD W=10u L=1u
Mp363 n363 n362 vdd vdd PMOD W=20u L=1u
CL363 n363 0 0.01p
Mn364 n364 n363 0 0 NMOD W=10u L=1u
Mp364 n364 n363 vdd vdd PMOD W=20u L=1u
CL364 n364 0 0.01p
Mn365 n365 n364 0 0 NMOD W=10u L=1u
Mp365 n365 n364 vdd vdd PMOD W=20u L=1u
CL365 n365 0 0.01p
Mn366 n366 n365 0 0 NMOD W=10u L=1u
Mp366 n366 n365 vdd vdd PMOD W=20u L=1u
CL366 n366 0 0.01p
Mn367 n367 n366 0 0 NMOD W=10u L=1u
Mp367 n367 n366 vdd vdd PMOD W=20u L=1u
CL367 n367 0 0.01p
Mn368 n368 n367 0 0 NMOD W=10u L=1u
Mp368 n368 n367 vdd vdd PMOD W=20u L=1u
CL368 n368 0 0.01p
Mn369 n369 n368 0 0 NMOD W=10u L=1u
Mp369 n369 n368 vdd vdd PMOD W=20u L=1u
CL369 n369 0 0.01p
Mn370 n370 n369 0 0 NMOD W=10u L=1u
Mp370 n370 n369 vdd vdd PMOD W=20u L=1u
CL370 n370 0 0.01p
Mn371 n371 n370 0 0 NMOD W=10u L=1u
Mp371 n371 n370 vdd vdd PMOD W=20u L=1u
CL371 n371 0 0.01p
Mn372 n372 n371 0 0 NMOD W=10u L=1u
Mp372 n372 n371 vdd vdd PMOD W=20u L=1u
CL372 n372 0 0.01p
Mn373 n373 n372 0 0 NMOD W=10u L=1u
Mp373 n373 n372 vdd vdd PMOD W=20u L=1u
CL373 n373 0 0.01p
Mn374 n374 n373 0 0 NMOD W=10u L=1u
Mp374 n374 n373 vdd vdd PMOD W=20u L=1u
CL374 n374 0 0.01p
Mn375 n375 n374 0 0 NMOD W=10u L=1u
Mp375 n375 n374 vdd vdd PMOD W=20u L=1u
CL375 n375 0 0.01p
Mn376 n376 n375 0 0 NMOD W=10u L=1u
Mp376 n376 n375 vdd vdd PMOD W=20u L=1u
CL376 n376 0 0.01p
Mn377 n377 n376 0 0 NMOD W=10u L=1u
Mp377 n377 n376 vdd vdd PMOD W=20u L=1u
CL377 n377 0 0.01p
Mn378 n378 n377 0 0 NMOD W=10u L=1u
Mp378 n378 n377 vdd vdd PMOD W=20u L=1u
CL378 n378 0 0.01p
Mn379 n379 n378 0 0 NMOD W=10u L=1u
Mp379 n379 n378 vdd vdd PMOD W=20u L=1u
CL379 n379 0 0.01p
Mn380 n380 n379 0 0 NMOD W=10u L=1u
Mp380 n380 n379 vdd vdd PMOD W=20u L=1u
CL380 n380 0 0.01p
Mn381 n381 n380 0 0 NMOD W=10u L=1u
Mp381 n381 n380 vdd vdd PMOD W=20u L=1u
CL381 n381 0 0.01p
Mn382 n382 n381 0 0 NMOD W=10u L=1u
Mp382 n382 n381 vdd vdd PMOD W=20u L=1u
CL382 n382 0 0.01p
Mn383 n383 n382 0 0 NMOD W=10u L=1u
Mp383 n383 n382 vdd vdd PMOD W=20u L=1u
CL383 n383 0 0.01p
Mn384 n384 n383 0 0 NMOD W=10u L=1u
Mp384 n384 n383 vdd vdd PMOD W=20u L=1u
CL384 n384 0 0.01p
Mn385 n385 n384 0 0 NMOD W=10u L=1u
Mp385 n385 n384 vdd vdd PMOD W=20u L=1u
CL385 n385 0 0.01p
Mn386 n386 n385 0 0 NMOD W=10u L=1u
Mp386 n386 n385 vdd vdd PMOD W=20u L=1u
CL386 n386 0 0.01p
Mn387 n387 n386 0 0 NMOD W=10u L=1u
Mp387 n387 n386 vdd vdd PMOD W=20u L=1u
CL387 n387 0 0.01p
Mn388 n388 n387 0 0 NMOD W=10u L=1u
Mp388 n388 n387 vdd vdd PMOD W=20u L=1u
CL388 n388 0 0.01p
Mn389 n389 n388 0 0 NMOD W=10u L=1u
Mp389 n389 n388 vdd vdd PMOD W=20u L=1u
CL389 n389 0 0.01p
Mn390 n390 n389 0 0 NMOD W=10u L=1u
Mp390 n390 n389 vdd vdd PMOD W=20u L=1u
CL390 n390 0 0.01p
Mn391 n391 n390 0 0 NMOD W=10u L=1u
Mp391 n391 n390 vdd vdd PMOD W=20u L=1u
CL391 n391 0 0.01p
Mn392 n392 n391 0 0 NMOD W=10u L=1u
Mp392 n392 n391 vdd vdd PMOD W=20u L=1u
CL392 n392 0 0.01p
Mn393 n393 n392 0 0 NMOD W=10u L=1u
Mp393 n393 n392 vdd vdd PMOD W=20u L=1u
CL393 n393 0 0.01p
Mn394 n394 n393 0 0 NMOD W=10u L=1u
Mp394 n394 n393 vdd vdd PMOD W=20u L=1u
CL394 n394 0 0.01p
Mn395 n395 n394 0 0 NMOD W=10u L=1u
Mp395 n395 n394 vdd vdd PMOD W=20u L=1u
CL395 n395 0 0.01p
Mn396 n396 n395 0 0 NMOD W=10u L=1u
Mp396 n396 n395 vdd vdd PMOD W=20u L=1u
CL396 n396 0 0.01p
Mn397 n397 n396 0 0 NMOD W=10u L=1u
Mp397 n397 n396 vdd vdd PMOD W=20u L=1u
CL397 n397 0 0.01p
Mn398 n398 n397 0 0 NMOD W=10u L=1u
Mp398 n398 n397 vdd vdd PMOD W=20u L=1u
CL398 n398 0 0.01p
Mn399 n399 n398 0 0 NMOD W=10u L=1u
Mp399 n399 n398 vdd vdd PMOD W=20u L=1u
CL399 n399 0 0.01p
Mn400 n400 n399 0 0 NMOD W=10u L=1u
Mp400 n400 n399 vdd vdd PMOD W=20u L=1u
CL400 n400 0 0.01p
Mn401 n401 n400 0 0 NMOD W=10u L=1u
Mp401 n401 n400 vdd vdd PMOD W=20u L=1u
CL401 n401 0 0.01p
Mn402 n402 n401 0 0 NMOD W=10u L=1u
Mp402 n402 n401 vdd vdd PMOD W=20u L=1u
CL402 n402 0 0.01p
Mn403 n403 n402 0 0 NMOD W=10u L=1u
Mp403 n403 n402 vdd vdd PMOD W=20u L=1u
CL403 n403 0 0.01p
Mn404 n404 n403 0 0 NMOD W=10u L=1u
Mp404 n404 n403 vdd vdd PMOD W=20u L=1u
CL404 n404 0 0.01p
Mn405 n405 n404 0 0 NMOD W=10u L=1u
Mp405 n405 n404 vdd vdd PMOD W=20u L=1u
CL405 n405 0 0.01p
Mn406 n406 n405 0 0 NMOD W=10u L=1u
Mp406 n406 n405 vdd vdd PMOD W=20u L=1u
CL406 n406 0 0.01p
Mn407 n407 n406 0 0 NMOD W=10u L=1u
Mp407 n407 n406 vdd vdd PMOD W=20u L=1u
CL407 n407 0 0.01p
Mn408 n408 n407 0 0 NMOD W=10u L=1u
Mp408 n408 n407 vdd vdd PMOD W=20u L=1u
CL408 n408 0 0.01p
Mn409 n409 n408 0 0 NMOD W=10u L=1u
Mp409 n409 n408 vdd vdd PMOD W=20u L=1u
CL409 n409 0 0.01p
Mn410 n410 n409 0 0 NMOD W=10u L=1u
Mp410 n410 n409 vdd vdd PMOD W=20u L=1u
CL410 n410 0 0.01p
Mn411 n411 n410 0 0 NMOD W=10u L=1u
Mp411 n411 n410 vdd vdd PMOD W=20u L=1u
CL411 n411 0 0.01p
Mn412 n412 n411 0 0 NMOD W=10u L=1u
Mp412 n412 n411 vdd vdd PMOD W=20u L=1u
CL412 n412 0 0.01p
Mn413 n413 n412 0 0 NMOD W=10u L=1u
Mp413 n413 n412 vdd vdd PMOD W=20u L=1u
CL413 n413 0 0.01p
Mn414 n414 n413 0 0 NMOD W=10u L=1u
Mp414 n414 n413 vdd vdd PMOD W=20u L=1u
CL414 n414 0 0.01p
Mn415 n415 n414 0 0 NMOD W=10u L=1u
Mp415 n415 n414 vdd vdd PMOD W=20u L=1u
CL415 n415 0 0.01p
Mn416 n416 n415 0 0 NMOD W=10u L=1u
Mp416 n416 n415 vdd vdd PMOD W=20u L=1u
CL416 n416 0 0.01p
Mn417 n417 n416 0 0 NMOD W=10u L=1u
Mp417 n417 n416 vdd vdd PMOD W=20u L=1u
CL417 n417 0 0.01p
Mn418 n418 n417 0 0 NMOD W=10u L=1u
Mp418 n418 n417 vdd vdd PMOD W=20u L=1u
CL418 n418 0 0.01p
Mn419 n419 n418 0 0 NMOD W=10u L=1u
Mp419 n419 n418 vdd vdd PMOD W=20u L=1u
CL419 n419 0 0.01p
Mn420 n420 n419 0 0 NMOD W=10u L=1u
Mp420 n420 n419 vdd vdd PMOD W=20u L=1u
CL420 n420 0 0.01p
Mn421 n421 n420 0 0 NMOD W=10u L=1u
Mp421 n421 n420 vdd vdd PMOD W=20u L=1u
CL421 n421 0 0.01p
Mn422 n422 n421 0 0 NMOD W=10u L=1u
Mp422 n422 n421 vdd vdd PMOD W=20u L=1u
CL422 n422 0 0.01p
Mn423 n423 n422 0 0 NMOD W=10u L=1u
Mp423 n423 n422 vdd vdd PMOD W=20u L=1u
CL423 n423 0 0.01p
Mn424 n424 n423 0 0 NMOD W=10u L=1u
Mp424 n424 n423 vdd vdd PMOD W=20u L=1u
CL424 n424 0 0.01p
Mn425 n425 n424 0 0 NMOD W=10u L=1u
Mp425 n425 n424 vdd vdd PMOD W=20u L=1u
CL425 n425 0 0.01p
Mn426 n426 n425 0 0 NMOD W=10u L=1u
Mp426 n426 n425 vdd vdd PMOD W=20u L=1u
CL426 n426 0 0.01p
Mn427 n427 n426 0 0 NMOD W=10u L=1u
Mp427 n427 n426 vdd vdd PMOD W=20u L=1u
CL427 n427 0 0.01p
Mn428 n428 n427 0 0 NMOD W=10u L=1u
Mp428 n428 n427 vdd vdd PMOD W=20u L=1u
CL428 n428 0 0.01p
Mn429 n429 n428 0 0 NMOD W=10u L=1u
Mp429 n429 n428 vdd vdd PMOD W=20u L=1u
CL429 n429 0 0.01p
Mn430 n430 n429 0 0 NMOD W=10u L=1u
Mp430 n430 n429 vdd vdd PMOD W=20u L=1u
CL430 n430 0 0.01p
Mn431 n431 n430 0 0 NMOD W=10u L=1u
Mp431 n431 n430 vdd vdd PMOD W=20u L=1u
CL431 n431 0 0.01p
Mn432 n432 n431 0 0 NMOD W=10u L=1u
Mp432 n432 n431 vdd vdd PMOD W=20u L=1u
CL432 n432 0 0.01p
Mn433 n433 n432 0 0 NMOD W=10u L=1u
Mp433 n433 n432 vdd vdd PMOD W=20u L=1u
CL433 n433 0 0.01p
Mn434 n434 n433 0 0 NMOD W=10u L=1u
Mp434 n434 n433 vdd vdd PMOD W=20u L=1u
CL434 n434 0 0.01p
Mn435 n435 n434 0 0 NMOD W=10u L=1u
Mp435 n435 n434 vdd vdd PMOD W=20u L=1u
CL435 n435 0 0.01p
Mn436 n436 n435 0 0 NMOD W=10u L=1u
Mp436 n436 n435 vdd vdd PMOD W=20u L=1u
CL436 n436 0 0.01p
Mn437 n437 n436 0 0 NMOD W=10u L=1u
Mp437 n437 n436 vdd vdd PMOD W=20u L=1u
CL437 n437 0 0.01p
Mn438 n438 n437 0 0 NMOD W=10u L=1u
Mp438 n438 n437 vdd vdd PMOD W=20u L=1u
CL438 n438 0 0.01p
Mn439 n439 n438 0 0 NMOD W=10u L=1u
Mp439 n439 n438 vdd vdd PMOD W=20u L=1u
CL439 n439 0 0.01p
Mn440 n440 n439 0 0 NMOD W=10u L=1u
Mp440 n440 n439 vdd vdd PMOD W=20u L=1u
CL440 n440 0 0.01p
Mn441 n441 n440 0 0 NMOD W=10u L=1u
Mp441 n441 n440 vdd vdd PMOD W=20u L=1u
CL441 n441 0 0.01p
Mn442 n442 n441 0 0 NMOD W=10u L=1u
Mp442 n442 n441 vdd vdd PMOD W=20u L=1u
CL442 n442 0 0.01p
Mn443 n443 n442 0 0 NMOD W=10u L=1u
Mp443 n443 n442 vdd vdd PMOD W=20u L=1u
CL443 n443 0 0.01p
Mn444 n444 n443 0 0 NMOD W=10u L=1u
Mp444 n444 n443 vdd vdd PMOD W=20u L=1u
CL444 n444 0 0.01p
Mn445 n445 n444 0 0 NMOD W=10u L=1u
Mp445 n445 n444 vdd vdd PMOD W=20u L=1u
CL445 n445 0 0.01p
Mn446 n446 n445 0 0 NMOD W=10u L=1u
Mp446 n446 n445 vdd vdd PMOD W=20u L=1u
CL446 n446 0 0.01p
Mn447 n447 n446 0 0 NMOD W=10u L=1u
Mp447 n447 n446 vdd vdd PMOD W=20u L=1u
CL447 n447 0 0.01p
Mn448 n448 n447 0 0 NMOD W=10u L=1u
Mp448 n448 n447 vdd vdd PMOD W=20u L=1u
CL448 n448 0 0.01p
Mn449 n449 n448 0 0 NMOD W=10u L=1u
Mp449 n449 n448 vdd vdd PMOD W=20u L=1u
CL449 n449 0 0.01p
Mn450 n450 n449 0 0 NMOD W=10u L=1u
Mp450 n450 n449 vdd vdd PMOD W=20u L=1u
CL450 n450 0 0.01p
Mn451 n451 n450 0 0 NMOD W=10u L=1u
Mp451 n451 n450 vdd vdd PMOD W=20u L=1u
CL451 n451 0 0.01p
Mn452 n452 n451 0 0 NMOD W=10u L=1u
Mp452 n452 n451 vdd vdd PMOD W=20u L=1u
CL452 n452 0 0.01p
Mn453 n453 n452 0 0 NMOD W=10u L=1u
Mp453 n453 n452 vdd vdd PMOD W=20u L=1u
CL453 n453 0 0.01p
Mn454 n454 n453 0 0 NMOD W=10u L=1u
Mp454 n454 n453 vdd vdd PMOD W=20u L=1u
CL454 n454 0 0.01p
Mn455 n455 n454 0 0 NMOD W=10u L=1u
Mp455 n455 n454 vdd vdd PMOD W=20u L=1u
CL455 n455 0 0.01p
Mn456 n456 n455 0 0 NMOD W=10u L=1u
Mp456 n456 n455 vdd vdd PMOD W=20u L=1u
CL456 n456 0 0.01p
Mn457 n457 n456 0 0 NMOD W=10u L=1u
Mp457 n457 n456 vdd vdd PMOD W=20u L=1u
CL457 n457 0 0.01p
Mn458 n458 n457 0 0 NMOD W=10u L=1u
Mp458 n458 n457 vdd vdd PMOD W=20u L=1u
CL458 n458 0 0.01p
Mn459 n459 n458 0 0 NMOD W=10u L=1u
Mp459 n459 n458 vdd vdd PMOD W=20u L=1u
CL459 n459 0 0.01p
Mn460 n460 n459 0 0 NMOD W=10u L=1u
Mp460 n460 n459 vdd vdd PMOD W=20u L=1u
CL460 n460 0 0.01p
Mn461 n461 n460 0 0 NMOD W=10u L=1u
Mp461 n461 n460 vdd vdd PMOD W=20u L=1u
CL461 n461 0 0.01p
Mn462 n462 n461 0 0 NMOD W=10u L=1u
Mp462 n462 n461 vdd vdd PMOD W=20u L=1u
CL462 n462 0 0.01p
Mn463 n463 n462 0 0 NMOD W=10u L=1u
Mp463 n463 n462 vdd vdd PMOD W=20u L=1u
CL463 n463 0 0.01p
Mn464 n464 n463 0 0 NMOD W=10u L=1u
Mp464 n464 n463 vdd vdd PMOD W=20u L=1u
CL464 n464 0 0.01p
Mn465 n465 n464 0 0 NMOD W=10u L=1u
Mp465 n465 n464 vdd vdd PMOD W=20u L=1u
CL465 n465 0 0.01p
Mn466 n466 n465 0 0 NMOD W=10u L=1u
Mp466 n466 n465 vdd vdd PMOD W=20u L=1u
CL466 n466 0 0.01p
Mn467 n467 n466 0 0 NMOD W=10u L=1u
Mp467 n467 n466 vdd vdd PMOD W=20u L=1u
CL467 n467 0 0.01p
Mn468 n468 n467 0 0 NMOD W=10u L=1u
Mp468 n468 n467 vdd vdd PMOD W=20u L=1u
CL468 n468 0 0.01p
Mn469 n469 n468 0 0 NMOD W=10u L=1u
Mp469 n469 n468 vdd vdd PMOD W=20u L=1u
CL469 n469 0 0.01p
Mn470 n470 n469 0 0 NMOD W=10u L=1u
Mp470 n470 n469 vdd vdd PMOD W=20u L=1u
CL470 n470 0 0.01p
Mn471 n471 n470 0 0 NMOD W=10u L=1u
Mp471 n471 n470 vdd vdd PMOD W=20u L=1u
CL471 n471 0 0.01p
Mn472 n472 n471 0 0 NMOD W=10u L=1u
Mp472 n472 n471 vdd vdd PMOD W=20u L=1u
CL472 n472 0 0.01p
Mn473 n473 n472 0 0 NMOD W=10u L=1u
Mp473 n473 n472 vdd vdd PMOD W=20u L=1u
CL473 n473 0 0.01p
Mn474 n474 n473 0 0 NMOD W=10u L=1u
Mp474 n474 n473 vdd vdd PMOD W=20u L=1u
CL474 n474 0 0.01p
Mn475 n475 n474 0 0 NMOD W=10u L=1u
Mp475 n475 n474 vdd vdd PMOD W=20u L=1u
CL475 n475 0 0.01p
Mn476 n476 n475 0 0 NMOD W=10u L=1u
Mp476 n476 n475 vdd vdd PMOD W=20u L=1u
CL476 n476 0 0.01p
Mn477 n477 n476 0 0 NMOD W=10u L=1u
Mp477 n477 n476 vdd vdd PMOD W=20u L=1u
CL477 n477 0 0.01p
Mn478 n478 n477 0 0 NMOD W=10u L=1u
Mp478 n478 n477 vdd vdd PMOD W=20u L=1u
CL478 n478 0 0.01p
Mn479 n479 n478 0 0 NMOD W=10u L=1u
Mp479 n479 n478 vdd vdd PMOD W=20u L=1u
CL479 n479 0 0.01p
Mn480 n480 n479 0 0 NMOD W=10u L=1u
Mp480 n480 n479 vdd vdd PMOD W=20u L=1u
CL480 n480 0 0.01p
Mn481 n481 n480 0 0 NMOD W=10u L=1u
Mp481 n481 n480 vdd vdd PMOD W=20u L=1u
CL481 n481 0 0.01p
Mn482 n482 n481 0 0 NMOD W=10u L=1u
Mp482 n482 n481 vdd vdd PMOD W=20u L=1u
CL482 n482 0 0.01p
Mn483 n483 n482 0 0 NMOD W=10u L=1u
Mp483 n483 n482 vdd vdd PMOD W=20u L=1u
CL483 n483 0 0.01p
Mn484 n484 n483 0 0 NMOD W=10u L=1u
Mp484 n484 n483 vdd vdd PMOD W=20u L=1u
CL484 n484 0 0.01p
Mn485 n485 n484 0 0 NMOD W=10u L=1u
Mp485 n485 n484 vdd vdd PMOD W=20u L=1u
CL485 n485 0 0.01p
Mn486 n486 n485 0 0 NMOD W=10u L=1u
Mp486 n486 n485 vdd vdd PMOD W=20u L=1u
CL486 n486 0 0.01p
Mn487 n487 n486 0 0 NMOD W=10u L=1u
Mp487 n487 n486 vdd vdd PMOD W=20u L=1u
CL487 n487 0 0.01p
Mn488 n488 n487 0 0 NMOD W=10u L=1u
Mp488 n488 n487 vdd vdd PMOD W=20u L=1u
CL488 n488 0 0.01p
Mn489 n489 n488 0 0 NMOD W=10u L=1u
Mp489 n489 n488 vdd vdd PMOD W=20u L=1u
CL489 n489 0 0.01p
Mn490 n490 n489 0 0 NMOD W=10u L=1u
Mp490 n490 n489 vdd vdd PMOD W=20u L=1u
CL490 n490 0 0.01p
Mn491 n491 n490 0 0 NMOD W=10u L=1u
Mp491 n491 n490 vdd vdd PMOD W=20u L=1u
CL491 n491 0 0.01p
Mn492 n492 n491 0 0 NMOD W=10u L=1u
Mp492 n492 n491 vdd vdd PMOD W=20u L=1u
CL492 n492 0 0.01p
Mn493 n493 n492 0 0 NMOD W=10u L=1u
Mp493 n493 n492 vdd vdd PMOD W=20u L=1u
CL493 n493 0 0.01p
Mn494 n494 n493 0 0 NMOD W=10u L=1u
Mp494 n494 n493 vdd vdd PMOD W=20u L=1u
CL494 n494 0 0.01p
Mn495 n495 n494 0 0 NMOD W=10u L=1u
Mp495 n495 n494 vdd vdd PMOD W=20u L=1u
CL495 n495 0 0.01p
Mn496 n496 n495 0 0 NMOD W=10u L=1u
Mp496 n496 n495 vdd vdd PMOD W=20u L=1u
CL496 n496 0 0.01p
Mn497 n497 n496 0 0 NMOD W=10u L=1u
Mp497 n497 n496 vdd vdd PMOD W=20u L=1u
CL497 n497 0 0.01p
Mn498 n498 n497 0 0 NMOD W=10u L=1u
Mp498 n498 n497 vdd vdd PMOD W=20u L=1u
CL498 n498 0 0.01p
Mn499 n499 n498 0 0 NMOD W=10u L=1u
Mp499 n499 n498 vdd vdd PMOD W=20u L=1u
CL499 n499 0 0.01p
Mn500 n500 n499 0 0 NMOD W=10u L=1u
Mp500 n500 n499 vdd vdd PMOD W=20u L=1u
CL500 n500 0 0.01p
Mn501 n501 n500 0 0 NMOD W=10u L=1u
Mp501 n501 n500 vdd vdd PMOD W=20u L=1u
CL501 n501 0 0.01p
Mn502 n502 n501 0 0 NMOD W=10u L=1u
Mp502 n502 n501 vdd vdd PMOD W=20u L=1u
CL502 n502 0 0.01p
Mn503 n503 n502 0 0 NMOD W=10u L=1u
Mp503 n503 n502 vdd vdd PMOD W=20u L=1u
CL503 n503 0 0.01p
Mn504 n504 n503 0 0 NMOD W=10u L=1u
Mp504 n504 n503 vdd vdd PMOD W=20u L=1u
CL504 n504 0 0.01p
Mn505 n505 n504 0 0 NMOD W=10u L=1u
Mp505 n505 n504 vdd vdd PMOD W=20u L=1u
CL505 n505 0 0.01p
Mn506 n506 n505 0 0 NMOD W=10u L=1u
Mp506 n506 n505 vdd vdd PMOD W=20u L=1u
CL506 n506 0 0.01p
Mn507 n507 n506 0 0 NMOD W=10u L=1u
Mp507 n507 n506 vdd vdd PMOD W=20u L=1u
CL507 n507 0 0.01p
Mn508 n508 n507 0 0 NMOD W=10u L=1u
Mp508 n508 n507 vdd vdd PMOD W=20u L=1u
CL508 n508 0 0.01p
Mn509 n509 n508 0 0 NMOD W=10u L=1u
Mp509 n509 n508 vdd vdd PMOD W=20u L=1u
CL509 n509 0 0.01p
Mn510 n510 n509 0 0 NMOD W=10u L=1u
Mp510 n510 n509 vdd vdd PMOD W=20u L=1u
CL510 n510 0 0.01p
Mn511 n511 n510 0 0 NMOD W=10u L=1u
Mp511 n511 n510 vdd vdd PMOD W=20u L=1u
CL511 n511 0 0.01p
Mn512 n512 n511 0 0 NMOD W=10u L=1u
Mp512 n512 n511 vdd vdd PMOD W=20u L=1u
CL512 n512 0 0.01p
Mn513 n513 n512 0 0 NMOD W=10u L=1u
Mp513 n513 n512 vdd vdd PMOD W=20u L=1u
CL513 n513 0 0.01p
Mn514 n514 n513 0 0 NMOD W=10u L=1u
Mp514 n514 n513 vdd vdd PMOD W=20u L=1u
CL514 n514 0 0.01p
Mn515 n515 n514 0 0 NMOD W=10u L=1u
Mp515 n515 n514 vdd vdd PMOD W=20u L=1u
CL515 n515 0 0.01p
Mn516 n516 n515 0 0 NMOD W=10u L=1u
Mp516 n516 n515 vdd vdd PMOD W=20u L=1u
CL516 n516 0 0.01p
Mn517 n517 n516 0 0 NMOD W=10u L=1u
Mp517 n517 n516 vdd vdd PMOD W=20u L=1u
CL517 n517 0 0.01p
Mn518 n518 n517 0 0 NMOD W=10u L=1u
Mp518 n518 n517 vdd vdd PMOD W=20u L=1u
CL518 n518 0 0.01p
Mn519 n519 n518 0 0 NMOD W=10u L=1u
Mp519 n519 n518 vdd vdd PMOD W=20u L=1u
CL519 n519 0 0.01p
Mn520 n520 n519 0 0 NMOD W=10u L=1u
Mp520 n520 n519 vdd vdd PMOD W=20u L=1u
CL520 n520 0 0.01p
Mn521 n521 n520 0 0 NMOD W=10u L=1u
Mp521 n521 n520 vdd vdd PMOD W=20u L=1u
CL521 n521 0 0.01p
Mn522 n522 n521 0 0 NMOD W=10u L=1u
Mp522 n522 n521 vdd vdd PMOD W=20u L=1u
CL522 n522 0 0.01p
Mn523 n523 n522 0 0 NMOD W=10u L=1u
Mp523 n523 n522 vdd vdd PMOD W=20u L=1u
CL523 n523 0 0.01p
Mn524 n524 n523 0 0 NMOD W=10u L=1u
Mp524 n524 n523 vdd vdd PMOD W=20u L=1u
CL524 n524 0 0.01p
Mn525 n525 n524 0 0 NMOD W=10u L=1u
Mp525 n525 n524 vdd vdd PMOD W=20u L=1u
CL525 n525 0 0.01p
Mn526 n526 n525 0 0 NMOD W=10u L=1u
Mp526 n526 n525 vdd vdd PMOD W=20u L=1u
CL526 n526 0 0.01p
Mn527 n527 n526 0 0 NMOD W=10u L=1u
Mp527 n527 n526 vdd vdd PMOD W=20u L=1u
CL527 n527 0 0.01p
Mn528 n528 n527 0 0 NMOD W=10u L=1u
Mp528 n528 n527 vdd vdd PMOD W=20u L=1u
CL528 n528 0 0.01p
Mn529 n529 n528 0 0 NMOD W=10u L=1u
Mp529 n529 n528 vdd vdd PMOD W=20u L=1u
CL529 n529 0 0.01p
Mn530 n530 n529 0 0 NMOD W=10u L=1u
Mp530 n530 n529 vdd vdd PMOD W=20u L=1u
CL530 n530 0 0.01p
Mn531 n531 n530 0 0 NMOD W=10u L=1u
Mp531 n531 n530 vdd vdd PMOD W=20u L=1u
CL531 n531 0 0.01p
Mn532 n532 n531 0 0 NMOD W=10u L=1u
Mp532 n532 n531 vdd vdd PMOD W=20u L=1u
CL532 n532 0 0.01p
Mn533 n533 n532 0 0 NMOD W=10u L=1u
Mp533 n533 n532 vdd vdd PMOD W=20u L=1u
CL533 n533 0 0.01p
Mn534 n534 n533 0 0 NMOD W=10u L=1u
Mp534 n534 n533 vdd vdd PMOD W=20u L=1u
CL534 n534 0 0.01p
Mn535 n535 n534 0 0 NMOD W=10u L=1u
Mp535 n535 n534 vdd vdd PMOD W=20u L=1u
CL535 n535 0 0.01p
Mn536 n536 n535 0 0 NMOD W=10u L=1u
Mp536 n536 n535 vdd vdd PMOD W=20u L=1u
CL536 n536 0 0.01p
Mn537 n537 n536 0 0 NMOD W=10u L=1u
Mp537 n537 n536 vdd vdd PMOD W=20u L=1u
CL537 n537 0 0.01p
Mn538 n538 n537 0 0 NMOD W=10u L=1u
Mp538 n538 n537 vdd vdd PMOD W=20u L=1u
CL538 n538 0 0.01p
Mn539 n539 n538 0 0 NMOD W=10u L=1u
Mp539 n539 n538 vdd vdd PMOD W=20u L=1u
CL539 n539 0 0.01p
Mn540 n540 n539 0 0 NMOD W=10u L=1u
Mp540 n540 n539 vdd vdd PMOD W=20u L=1u
CL540 n540 0 0.01p
Mn541 n541 n540 0 0 NMOD W=10u L=1u
Mp541 n541 n540 vdd vdd PMOD W=20u L=1u
CL541 n541 0 0.01p
Mn542 n542 n541 0 0 NMOD W=10u L=1u
Mp542 n542 n541 vdd vdd PMOD W=20u L=1u
CL542 n542 0 0.01p
Mn543 n543 n542 0 0 NMOD W=10u L=1u
Mp543 n543 n542 vdd vdd PMOD W=20u L=1u
CL543 n543 0 0.01p
Mn544 n544 n543 0 0 NMOD W=10u L=1u
Mp544 n544 n543 vdd vdd PMOD W=20u L=1u
CL544 n544 0 0.01p
Mn545 n545 n544 0 0 NMOD W=10u L=1u
Mp545 n545 n544 vdd vdd PMOD W=20u L=1u
CL545 n545 0 0.01p
Mn546 n546 n545 0 0 NMOD W=10u L=1u
Mp546 n546 n545 vdd vdd PMOD W=20u L=1u
CL546 n546 0 0.01p
Mn547 n547 n546 0 0 NMOD W=10u L=1u
Mp547 n547 n546 vdd vdd PMOD W=20u L=1u
CL547 n547 0 0.01p
Mn548 n548 n547 0 0 NMOD W=10u L=1u
Mp548 n548 n547 vdd vdd PMOD W=20u L=1u
CL548 n548 0 0.01p
Mn549 n549 n548 0 0 NMOD W=10u L=1u
Mp549 n549 n548 vdd vdd PMOD W=20u L=1u
CL549 n549 0 0.01p
Mn550 n550 n549 0 0 NMOD W=10u L=1u
Mp550 n550 n549 vdd vdd PMOD W=20u L=1u
CL550 n550 0 0.01p
Mn551 n551 n550 0 0 NMOD W=10u L=1u
Mp551 n551 n550 vdd vdd PMOD W=20u L=1u
CL551 n551 0 0.01p
Mn552 n552 n551 0 0 NMOD W=10u L=1u
Mp552 n552 n551 vdd vdd PMOD W=20u L=1u
CL552 n552 0 0.01p
Mn553 n553 n552 0 0 NMOD W=10u L=1u
Mp553 n553 n552 vdd vdd PMOD W=20u L=1u
CL553 n553 0 0.01p
Mn554 n554 n553 0 0 NMOD W=10u L=1u
Mp554 n554 n553 vdd vdd PMOD W=20u L=1u
CL554 n554 0 0.01p
Mn555 n555 n554 0 0 NMOD W=10u L=1u
Mp555 n555 n554 vdd vdd PMOD W=20u L=1u
CL555 n555 0 0.01p
Mn556 n556 n555 0 0 NMOD W=10u L=1u
Mp556 n556 n555 vdd vdd PMOD W=20u L=1u
CL556 n556 0 0.01p
Mn557 n557 n556 0 0 NMOD W=10u L=1u
Mp557 n557 n556 vdd vdd PMOD W=20u L=1u
CL557 n557 0 0.01p
Mn558 n558 n557 0 0 NMOD W=10u L=1u
Mp558 n558 n557 vdd vdd PMOD W=20u L=1u
CL558 n558 0 0.01p
Mn559 n559 n558 0 0 NMOD W=10u L=1u
Mp559 n559 n558 vdd vdd PMOD W=20u L=1u
CL559 n559 0 0.01p
Mn560 n560 n559 0 0 NMOD W=10u L=1u
Mp560 n560 n559 vdd vdd PMOD W=20u L=1u
CL560 n560 0 0.01p
Mn561 n561 n560 0 0 NMOD W=10u L=1u
Mp561 n561 n560 vdd vdd PMOD W=20u L=1u
CL561 n561 0 0.01p
Mn562 n562 n561 0 0 NMOD W=10u L=1u
Mp562 n562 n561 vdd vdd PMOD W=20u L=1u
CL562 n562 0 0.01p
Mn563 n563 n562 0 0 NMOD W=10u L=1u
Mp563 n563 n562 vdd vdd PMOD W=20u L=1u
CL563 n563 0 0.01p
Mn564 n564 n563 0 0 NMOD W=10u L=1u
Mp564 n564 n563 vdd vdd PMOD W=20u L=1u
CL564 n564 0 0.01p
Mn565 n565 n564 0 0 NMOD W=10u L=1u
Mp565 n565 n564 vdd vdd PMOD W=20u L=1u
CL565 n565 0 0.01p
Mn566 n566 n565 0 0 NMOD W=10u L=1u
Mp566 n566 n565 vdd vdd PMOD W=20u L=1u
CL566 n566 0 0.01p
Mn567 n567 n566 0 0 NMOD W=10u L=1u
Mp567 n567 n566 vdd vdd PMOD W=20u L=1u
CL567 n567 0 0.01p
Mn568 n568 n567 0 0 NMOD W=10u L=1u
Mp568 n568 n567 vdd vdd PMOD W=20u L=1u
CL568 n568 0 0.01p
Mn569 n569 n568 0 0 NMOD W=10u L=1u
Mp569 n569 n568 vdd vdd PMOD W=20u L=1u
CL569 n569 0 0.01p
Mn570 n570 n569 0 0 NMOD W=10u L=1u
Mp570 n570 n569 vdd vdd PMOD W=20u L=1u
CL570 n570 0 0.01p
Mn571 n571 n570 0 0 NMOD W=10u L=1u
Mp571 n571 n570 vdd vdd PMOD W=20u L=1u
CL571 n571 0 0.01p
Mn572 n572 n571 0 0 NMOD W=10u L=1u
Mp572 n572 n571 vdd vdd PMOD W=20u L=1u
CL572 n572 0 0.01p
Mn573 n573 n572 0 0 NMOD W=10u L=1u
Mp573 n573 n572 vdd vdd PMOD W=20u L=1u
CL573 n573 0 0.01p
Mn574 n574 n573 0 0 NMOD W=10u L=1u
Mp574 n574 n573 vdd vdd PMOD W=20u L=1u
CL574 n574 0 0.01p
Mn575 n575 n574 0 0 NMOD W=10u L=1u
Mp575 n575 n574 vdd vdd PMOD W=20u L=1u
CL575 n575 0 0.01p
Mn576 n576 n575 0 0 NMOD W=10u L=1u
Mp576 n576 n575 vdd vdd PMOD W=20u L=1u
CL576 n576 0 0.01p
Mn577 n577 n576 0 0 NMOD W=10u L=1u
Mp577 n577 n576 vdd vdd PMOD W=20u L=1u
CL577 n577 0 0.01p
Mn578 n578 n577 0 0 NMOD W=10u L=1u
Mp578 n578 n577 vdd vdd PMOD W=20u L=1u
CL578 n578 0 0.01p
Mn579 n579 n578 0 0 NMOD W=10u L=1u
Mp579 n579 n578 vdd vdd PMOD W=20u L=1u
CL579 n579 0 0.01p
Mn580 n580 n579 0 0 NMOD W=10u L=1u
Mp580 n580 n579 vdd vdd PMOD W=20u L=1u
CL580 n580 0 0.01p
Mn581 n581 n580 0 0 NMOD W=10u L=1u
Mp581 n581 n580 vdd vdd PMOD W=20u L=1u
CL581 n581 0 0.01p
Mn582 n582 n581 0 0 NMOD W=10u L=1u
Mp582 n582 n581 vdd vdd PMOD W=20u L=1u
CL582 n582 0 0.01p
Mn583 n583 n582 0 0 NMOD W=10u L=1u
Mp583 n583 n582 vdd vdd PMOD W=20u L=1u
CL583 n583 0 0.01p
Mn584 n584 n583 0 0 NMOD W=10u L=1u
Mp584 n584 n583 vdd vdd PMOD W=20u L=1u
CL584 n584 0 0.01p
Mn585 n585 n584 0 0 NMOD W=10u L=1u
Mp585 n585 n584 vdd vdd PMOD W=20u L=1u
CL585 n585 0 0.01p
Mn586 n586 n585 0 0 NMOD W=10u L=1u
Mp586 n586 n585 vdd vdd PMOD W=20u L=1u
CL586 n586 0 0.01p
Mn587 n587 n586 0 0 NMOD W=10u L=1u
Mp587 n587 n586 vdd vdd PMOD W=20u L=1u
CL587 n587 0 0.01p
Mn588 n588 n587 0 0 NMOD W=10u L=1u
Mp588 n588 n587 vdd vdd PMOD W=20u L=1u
CL588 n588 0 0.01p
Mn589 n589 n588 0 0 NMOD W=10u L=1u
Mp589 n589 n588 vdd vdd PMOD W=20u L=1u
CL589 n589 0 0.01p
Mn590 n590 n589 0 0 NMOD W=10u L=1u
Mp590 n590 n589 vdd vdd PMOD W=20u L=1u
CL590 n590 0 0.01p
Mn591 n591 n590 0 0 NMOD W=10u L=1u
Mp591 n591 n590 vdd vdd PMOD W=20u L=1u
CL591 n591 0 0.01p
Mn592 n592 n591 0 0 NMOD W=10u L=1u
Mp592 n592 n591 vdd vdd PMOD W=20u L=1u
CL592 n592 0 0.01p
Mn593 n593 n592 0 0 NMOD W=10u L=1u
Mp593 n593 n592 vdd vdd PMOD W=20u L=1u
CL593 n593 0 0.01p
Mn594 n594 n593 0 0 NMOD W=10u L=1u
Mp594 n594 n593 vdd vdd PMOD W=20u L=1u
CL594 n594 0 0.01p
Mn595 n595 n594 0 0 NMOD W=10u L=1u
Mp595 n595 n594 vdd vdd PMOD W=20u L=1u
CL595 n595 0 0.01p
Mn596 n596 n595 0 0 NMOD W=10u L=1u
Mp596 n596 n595 vdd vdd PMOD W=20u L=1u
CL596 n596 0 0.01p
Mn597 n597 n596 0 0 NMOD W=10u L=1u
Mp597 n597 n596 vdd vdd PMOD W=20u L=1u
CL597 n597 0 0.01p
Mn598 n598 n597 0 0 NMOD W=10u L=1u
Mp598 n598 n597 vdd vdd PMOD W=20u L=1u
CL598 n598 0 0.01p
Mn599 n599 n598 0 0 NMOD W=10u L=1u
Mp599 n599 n598 vdd vdd PMOD W=20u L=1u
CL599 n599 0 0.01p
Mn600 n600 n599 0 0 NMOD W=10u L=1u
Mp600 n600 n599 vdd vdd PMOD W=20u L=1u
CL600 n600 0 0.01p
Mn601 n601 n600 0 0 NMOD W=10u L=1u
Mp601 n601 n600 vdd vdd PMOD W=20u L=1u
CL601 n601 0 0.01p
Mn602 n602 n601 0 0 NMOD W=10u L=1u
Mp602 n602 n601 vdd vdd PMOD W=20u L=1u
CL602 n602 0 0.01p
Mn603 n603 n602 0 0 NMOD W=10u L=1u
Mp603 n603 n602 vdd vdd PMOD W=20u L=1u
CL603 n603 0 0.01p
Mn604 n604 n603 0 0 NMOD W=10u L=1u
Mp604 n604 n603 vdd vdd PMOD W=20u L=1u
CL604 n604 0 0.01p
Mn605 n605 n604 0 0 NMOD W=10u L=1u
Mp605 n605 n604 vdd vdd PMOD W=20u L=1u
CL605 n605 0 0.01p
Mn606 n606 n605 0 0 NMOD W=10u L=1u
Mp606 n606 n605 vdd vdd PMOD W=20u L=1u
CL606 n606 0 0.01p
Mn607 n607 n606 0 0 NMOD W=10u L=1u
Mp607 n607 n606 vdd vdd PMOD W=20u L=1u
CL607 n607 0 0.01p
Mn608 n608 n607 0 0 NMOD W=10u L=1u
Mp608 n608 n607 vdd vdd PMOD W=20u L=1u
CL608 n608 0 0.01p
Mn609 n609 n608 0 0 NMOD W=10u L=1u
Mp609 n609 n608 vdd vdd PMOD W=20u L=1u
CL609 n609 0 0.01p
Mn610 n610 n609 0 0 NMOD W=10u L=1u
Mp610 n610 n609 vdd vdd PMOD W=20u L=1u
CL610 n610 0 0.01p
Mn611 n611 n610 0 0 NMOD W=10u L=1u
Mp611 n611 n610 vdd vdd PMOD W=20u L=1u
CL611 n611 0 0.01p
Mn612 n612 n611 0 0 NMOD W=10u L=1u
Mp612 n612 n611 vdd vdd PMOD W=20u L=1u
CL612 n612 0 0.01p
Mn613 n613 n612 0 0 NMOD W=10u L=1u
Mp613 n613 n612 vdd vdd PMOD W=20u L=1u
CL613 n613 0 0.01p
Mn614 n614 n613 0 0 NMOD W=10u L=1u
Mp614 n614 n613 vdd vdd PMOD W=20u L=1u
CL614 n614 0 0.01p
Mn615 n615 n614 0 0 NMOD W=10u L=1u
Mp615 n615 n614 vdd vdd PMOD W=20u L=1u
CL615 n615 0 0.01p
Mn616 n616 n615 0 0 NMOD W=10u L=1u
Mp616 n616 n615 vdd vdd PMOD W=20u L=1u
CL616 n616 0 0.01p
Mn617 n617 n616 0 0 NMOD W=10u L=1u
Mp617 n617 n616 vdd vdd PMOD W=20u L=1u
CL617 n617 0 0.01p
Mn618 n618 n617 0 0 NMOD W=10u L=1u
Mp618 n618 n617 vdd vdd PMOD W=20u L=1u
CL618 n618 0 0.01p
Mn619 n619 n618 0 0 NMOD W=10u L=1u
Mp619 n619 n618 vdd vdd PMOD W=20u L=1u
CL619 n619 0 0.01p
Mn620 n620 n619 0 0 NMOD W=10u L=1u
Mp620 n620 n619 vdd vdd PMOD W=20u L=1u
CL620 n620 0 0.01p
Mn621 n621 n620 0 0 NMOD W=10u L=1u
Mp621 n621 n620 vdd vdd PMOD W=20u L=1u
CL621 n621 0 0.01p
Mn622 n622 n621 0 0 NMOD W=10u L=1u
Mp622 n622 n621 vdd vdd PMOD W=20u L=1u
CL622 n622 0 0.01p
Mn623 n623 n622 0 0 NMOD W=10u L=1u
Mp623 n623 n622 vdd vdd PMOD W=20u L=1u
CL623 n623 0 0.01p
Mn624 n624 n623 0 0 NMOD W=10u L=1u
Mp624 n624 n623 vdd vdd PMOD W=20u L=1u
CL624 n624 0 0.01p
Mn625 n625 n624 0 0 NMOD W=10u L=1u
Mp625 n625 n624 vdd vdd PMOD W=20u L=1u
CL625 n625 0 0.01p
Mn626 n626 n625 0 0 NMOD W=10u L=1u
Mp626 n626 n625 vdd vdd PMOD W=20u L=1u
CL626 n626 0 0.01p
Mn627 n627 n626 0 0 NMOD W=10u L=1u
Mp627 n627 n626 vdd vdd PMOD W=20u L=1u
CL627 n627 0 0.01p
Mn628 n628 n627 0 0 NMOD W=10u L=1u
Mp628 n628 n627 vdd vdd PMOD W=20u L=1u
CL628 n628 0 0.01p
Mn629 n629 n628 0 0 NMOD W=10u L=1u
Mp629 n629 n628 vdd vdd PMOD W=20u L=1u
CL629 n629 0 0.01p
Mn630 n630 n629 0 0 NMOD W=10u L=1u
Mp630 n630 n629 vdd vdd PMOD W=20u L=1u
CL630 n630 0 0.01p
Mn631 n631 n630 0 0 NMOD W=10u L=1u
Mp631 n631 n630 vdd vdd PMOD W=20u L=1u
CL631 n631 0 0.01p
Mn632 n632 n631 0 0 NMOD W=10u L=1u
Mp632 n632 n631 vdd vdd PMOD W=20u L=1u
CL632 n632 0 0.01p
Mn633 n633 n632 0 0 NMOD W=10u L=1u
Mp633 n633 n632 vdd vdd PMOD W=20u L=1u
CL633 n633 0 0.01p
Mn634 n634 n633 0 0 NMOD W=10u L=1u
Mp634 n634 n633 vdd vdd PMOD W=20u L=1u
CL634 n634 0 0.01p
Mn635 n635 n634 0 0 NMOD W=10u L=1u
Mp635 n635 n634 vdd vdd PMOD W=20u L=1u
CL635 n635 0 0.01p
Mn636 n636 n635 0 0 NMOD W=10u L=1u
Mp636 n636 n635 vdd vdd PMOD W=20u L=1u
CL636 n636 0 0.01p
Mn637 n637 n636 0 0 NMOD W=10u L=1u
Mp637 n637 n636 vdd vdd PMOD W=20u L=1u
CL637 n637 0 0.01p
Mn638 n638 n637 0 0 NMOD W=10u L=1u
Mp638 n638 n637 vdd vdd PMOD W=20u L=1u
CL638 n638 0 0.01p
Mn639 n639 n638 0 0 NMOD W=10u L=1u
Mp639 n639 n638 vdd vdd PMOD W=20u L=1u
CL639 n639 0 0.01p
Mn640 n640 n639 0 0 NMOD W=10u L=1u
Mp640 n640 n639 vdd vdd PMOD W=20u L=1u
CL640 n640 0 0.01p
Mn641 n641 n640 0 0 NMOD W=10u L=1u
Mp641 n641 n640 vdd vdd PMOD W=20u L=1u
CL641 n641 0 0.01p
Mn642 n642 n641 0 0 NMOD W=10u L=1u
Mp642 n642 n641 vdd vdd PMOD W=20u L=1u
CL642 n642 0 0.01p
Mn643 n643 n642 0 0 NMOD W=10u L=1u
Mp643 n643 n642 vdd vdd PMOD W=20u L=1u
CL643 n643 0 0.01p
Mn644 n644 n643 0 0 NMOD W=10u L=1u
Mp644 n644 n643 vdd vdd PMOD W=20u L=1u
CL644 n644 0 0.01p
Mn645 n645 n644 0 0 NMOD W=10u L=1u
Mp645 n645 n644 vdd vdd PMOD W=20u L=1u
CL645 n645 0 0.01p
Mn646 n646 n645 0 0 NMOD W=10u L=1u
Mp646 n646 n645 vdd vdd PMOD W=20u L=1u
CL646 n646 0 0.01p
Mn647 n647 n646 0 0 NMOD W=10u L=1u
Mp647 n647 n646 vdd vdd PMOD W=20u L=1u
CL647 n647 0 0.01p
Mn648 n648 n647 0 0 NMOD W=10u L=1u
Mp648 n648 n647 vdd vdd PMOD W=20u L=1u
CL648 n648 0 0.01p
Mn649 n649 n648 0 0 NMOD W=10u L=1u
Mp649 n649 n648 vdd vdd PMOD W=20u L=1u
CL649 n649 0 0.01p
Mn650 n650 n649 0 0 NMOD W=10u L=1u
Mp650 n650 n649 vdd vdd PMOD W=20u L=1u
CL650 n650 0 0.01p
Mn651 n651 n650 0 0 NMOD W=10u L=1u
Mp651 n651 n650 vdd vdd PMOD W=20u L=1u
CL651 n651 0 0.01p
Mn652 n652 n651 0 0 NMOD W=10u L=1u
Mp652 n652 n651 vdd vdd PMOD W=20u L=1u
CL652 n652 0 0.01p
Mn653 n653 n652 0 0 NMOD W=10u L=1u
Mp653 n653 n652 vdd vdd PMOD W=20u L=1u
CL653 n653 0 0.01p
Mn654 n654 n653 0 0 NMOD W=10u L=1u
Mp654 n654 n653 vdd vdd PMOD W=20u L=1u
CL654 n654 0 0.01p
Mn655 n655 n654 0 0 NMOD W=10u L=1u
Mp655 n655 n654 vdd vdd PMOD W=20u L=1u
CL655 n655 0 0.01p
Mn656 n656 n655 0 0 NMOD W=10u L=1u
Mp656 n656 n655 vdd vdd PMOD W=20u L=1u
CL656 n656 0 0.01p
Mn657 n657 n656 0 0 NMOD W=10u L=1u
Mp657 n657 n656 vdd vdd PMOD W=20u L=1u
CL657 n657 0 0.01p
Mn658 n658 n657 0 0 NMOD W=10u L=1u
Mp658 n658 n657 vdd vdd PMOD W=20u L=1u
CL658 n658 0 0.01p
Mn659 n659 n658 0 0 NMOD W=10u L=1u
Mp659 n659 n658 vdd vdd PMOD W=20u L=1u
CL659 n659 0 0.01p
Mn660 n660 n659 0 0 NMOD W=10u L=1u
Mp660 n660 n659 vdd vdd PMOD W=20u L=1u
CL660 n660 0 0.01p
Mn661 n661 n660 0 0 NMOD W=10u L=1u
Mp661 n661 n660 vdd vdd PMOD W=20u L=1u
CL661 n661 0 0.01p
Mn662 n662 n661 0 0 NMOD W=10u L=1u
Mp662 n662 n661 vdd vdd PMOD W=20u L=1u
CL662 n662 0 0.01p
Mn663 n663 n662 0 0 NMOD W=10u L=1u
Mp663 n663 n662 vdd vdd PMOD W=20u L=1u
CL663 n663 0 0.01p
Mn664 n664 n663 0 0 NMOD W=10u L=1u
Mp664 n664 n663 vdd vdd PMOD W=20u L=1u
CL664 n664 0 0.01p
Mn665 n665 n664 0 0 NMOD W=10u L=1u
Mp665 n665 n664 vdd vdd PMOD W=20u L=1u
CL665 n665 0 0.01p
Mn666 n666 n665 0 0 NMOD W=10u L=1u
Mp666 n666 n665 vdd vdd PMOD W=20u L=1u
CL666 n666 0 0.01p
Mn667 n667 n666 0 0 NMOD W=10u L=1u
Mp667 n667 n666 vdd vdd PMOD W=20u L=1u
CL667 n667 0 0.01p
Mn668 n668 n667 0 0 NMOD W=10u L=1u
Mp668 n668 n667 vdd vdd PMOD W=20u L=1u
CL668 n668 0 0.01p
Mn669 n669 n668 0 0 NMOD W=10u L=1u
Mp669 n669 n668 vdd vdd PMOD W=20u L=1u
CL669 n669 0 0.01p
Mn670 n670 n669 0 0 NMOD W=10u L=1u
Mp670 n670 n669 vdd vdd PMOD W=20u L=1u
CL670 n670 0 0.01p
Mn671 n671 n670 0 0 NMOD W=10u L=1u
Mp671 n671 n670 vdd vdd PMOD W=20u L=1u
CL671 n671 0 0.01p
Mn672 n672 n671 0 0 NMOD W=10u L=1u
Mp672 n672 n671 vdd vdd PMOD W=20u L=1u
CL672 n672 0 0.01p
Mn673 n673 n672 0 0 NMOD W=10u L=1u
Mp673 n673 n672 vdd vdd PMOD W=20u L=1u
CL673 n673 0 0.01p
Mn674 n674 n673 0 0 NMOD W=10u L=1u
Mp674 n674 n673 vdd vdd PMOD W=20u L=1u
CL674 n674 0 0.01p
Mn675 n675 n674 0 0 NMOD W=10u L=1u
Mp675 n675 n674 vdd vdd PMOD W=20u L=1u
CL675 n675 0 0.01p
Mn676 n676 n675 0 0 NMOD W=10u L=1u
Mp676 n676 n675 vdd vdd PMOD W=20u L=1u
CL676 n676 0 0.01p
Mn677 n677 n676 0 0 NMOD W=10u L=1u
Mp677 n677 n676 vdd vdd PMOD W=20u L=1u
CL677 n677 0 0.01p
Mn678 n678 n677 0 0 NMOD W=10u L=1u
Mp678 n678 n677 vdd vdd PMOD W=20u L=1u
CL678 n678 0 0.01p
Mn679 n679 n678 0 0 NMOD W=10u L=1u
Mp679 n679 n678 vdd vdd PMOD W=20u L=1u
CL679 n679 0 0.01p
Mn680 n680 n679 0 0 NMOD W=10u L=1u
Mp680 n680 n679 vdd vdd PMOD W=20u L=1u
CL680 n680 0 0.01p
Mn681 n681 n680 0 0 NMOD W=10u L=1u
Mp681 n681 n680 vdd vdd PMOD W=20u L=1u
CL681 n681 0 0.01p
Mn682 n682 n681 0 0 NMOD W=10u L=1u
Mp682 n682 n681 vdd vdd PMOD W=20u L=1u
CL682 n682 0 0.01p
Mn683 n683 n682 0 0 NMOD W=10u L=1u
Mp683 n683 n682 vdd vdd PMOD W=20u L=1u
CL683 n683 0 0.01p
Mn684 n684 n683 0 0 NMOD W=10u L=1u
Mp684 n684 n683 vdd vdd PMOD W=20u L=1u
CL684 n684 0 0.01p
Mn685 n685 n684 0 0 NMOD W=10u L=1u
Mp685 n685 n684 vdd vdd PMOD W=20u L=1u
CL685 n685 0 0.01p
Mn686 n686 n685 0 0 NMOD W=10u L=1u
Mp686 n686 n685 vdd vdd PMOD W=20u L=1u
CL686 n686 0 0.01p
Mn687 n687 n686 0 0 NMOD W=10u L=1u
Mp687 n687 n686 vdd vdd PMOD W=20u L=1u
CL687 n687 0 0.01p
Mn688 n688 n687 0 0 NMOD W=10u L=1u
Mp688 n688 n687 vdd vdd PMOD W=20u L=1u
CL688 n688 0 0.01p
Mn689 n689 n688 0 0 NMOD W=10u L=1u
Mp689 n689 n688 vdd vdd PMOD W=20u L=1u
CL689 n689 0 0.01p
Mn690 n690 n689 0 0 NMOD W=10u L=1u
Mp690 n690 n689 vdd vdd PMOD W=20u L=1u
CL690 n690 0 0.01p
Mn691 n691 n690 0 0 NMOD W=10u L=1u
Mp691 n691 n690 vdd vdd PMOD W=20u L=1u
CL691 n691 0 0.01p
Mn692 n692 n691 0 0 NMOD W=10u L=1u
Mp692 n692 n691 vdd vdd PMOD W=20u L=1u
CL692 n692 0 0.01p
Mn693 n693 n692 0 0 NMOD W=10u L=1u
Mp693 n693 n692 vdd vdd PMOD W=20u L=1u
CL693 n693 0 0.01p
Mn694 n694 n693 0 0 NMOD W=10u L=1u
Mp694 n694 n693 vdd vdd PMOD W=20u L=1u
CL694 n694 0 0.01p
Mn695 n695 n694 0 0 NMOD W=10u L=1u
Mp695 n695 n694 vdd vdd PMOD W=20u L=1u
CL695 n695 0 0.01p
Mn696 n696 n695 0 0 NMOD W=10u L=1u
Mp696 n696 n695 vdd vdd PMOD W=20u L=1u
CL696 n696 0 0.01p
Mn697 n697 n696 0 0 NMOD W=10u L=1u
Mp697 n697 n696 vdd vdd PMOD W=20u L=1u
CL697 n697 0 0.01p
Mn698 n698 n697 0 0 NMOD W=10u L=1u
Mp698 n698 n697 vdd vdd PMOD W=20u L=1u
CL698 n698 0 0.01p
Mn699 n699 n698 0 0 NMOD W=10u L=1u
Mp699 n699 n698 vdd vdd PMOD W=20u L=1u
CL699 n699 0 0.01p
Mn700 n700 n699 0 0 NMOD W=10u L=1u
Mp700 n700 n699 vdd vdd PMOD W=20u L=1u
CL700 n700 0 0.01p
Mn701 n701 n700 0 0 NMOD W=10u L=1u
Mp701 n701 n700 vdd vdd PMOD W=20u L=1u
CL701 n701 0 0.01p
Mn702 n702 n701 0 0 NMOD W=10u L=1u
Mp702 n702 n701 vdd vdd PMOD W=20u L=1u
CL702 n702 0 0.01p
Mn703 n703 n702 0 0 NMOD W=10u L=1u
Mp703 n703 n702 vdd vdd PMOD W=20u L=1u
CL703 n703 0 0.01p
Mn704 n704 n703 0 0 NMOD W=10u L=1u
Mp704 n704 n703 vdd vdd PMOD W=20u L=1u
CL704 n704 0 0.01p
Mn705 n705 n704 0 0 NMOD W=10u L=1u
Mp705 n705 n704 vdd vdd PMOD W=20u L=1u
CL705 n705 0 0.01p
Mn706 n706 n705 0 0 NMOD W=10u L=1u
Mp706 n706 n705 vdd vdd PMOD W=20u L=1u
CL706 n706 0 0.01p
Mn707 n707 n706 0 0 NMOD W=10u L=1u
Mp707 n707 n706 vdd vdd PMOD W=20u L=1u
CL707 n707 0 0.01p
Mn708 n708 n707 0 0 NMOD W=10u L=1u
Mp708 n708 n707 vdd vdd PMOD W=20u L=1u
CL708 n708 0 0.01p
Mn709 n709 n708 0 0 NMOD W=10u L=1u
Mp709 n709 n708 vdd vdd PMOD W=20u L=1u
CL709 n709 0 0.01p
Mn710 n710 n709 0 0 NMOD W=10u L=1u
Mp710 n710 n709 vdd vdd PMOD W=20u L=1u
CL710 n710 0 0.01p
Mn711 n711 n710 0 0 NMOD W=10u L=1u
Mp711 n711 n710 vdd vdd PMOD W=20u L=1u
CL711 n711 0 0.01p
Mn712 n712 n711 0 0 NMOD W=10u L=1u
Mp712 n712 n711 vdd vdd PMOD W=20u L=1u
CL712 n712 0 0.01p
Mn713 n713 n712 0 0 NMOD W=10u L=1u
Mp713 n713 n712 vdd vdd PMOD W=20u L=1u
CL713 n713 0 0.01p
Mn714 n714 n713 0 0 NMOD W=10u L=1u
Mp714 n714 n713 vdd vdd PMOD W=20u L=1u
CL714 n714 0 0.01p
Mn715 n715 n714 0 0 NMOD W=10u L=1u
Mp715 n715 n714 vdd vdd PMOD W=20u L=1u
CL715 n715 0 0.01p
Mn716 n716 n715 0 0 NMOD W=10u L=1u
Mp716 n716 n715 vdd vdd PMOD W=20u L=1u
CL716 n716 0 0.01p
Mn717 n717 n716 0 0 NMOD W=10u L=1u
Mp717 n717 n716 vdd vdd PMOD W=20u L=1u
CL717 n717 0 0.01p
Mn718 n718 n717 0 0 NMOD W=10u L=1u
Mp718 n718 n717 vdd vdd PMOD W=20u L=1u
CL718 n718 0 0.01p
Mn719 n719 n718 0 0 NMOD W=10u L=1u
Mp719 n719 n718 vdd vdd PMOD W=20u L=1u
CL719 n719 0 0.01p
Mn720 n720 n719 0 0 NMOD W=10u L=1u
Mp720 n720 n719 vdd vdd PMOD W=20u L=1u
CL720 n720 0 0.01p
Mn721 n721 n720 0 0 NMOD W=10u L=1u
Mp721 n721 n720 vdd vdd PMOD W=20u L=1u
CL721 n721 0 0.01p
Mn722 n722 n721 0 0 NMOD W=10u L=1u
Mp722 n722 n721 vdd vdd PMOD W=20u L=1u
CL722 n722 0 0.01p
Mn723 n723 n722 0 0 NMOD W=10u L=1u
Mp723 n723 n722 vdd vdd PMOD W=20u L=1u
CL723 n723 0 0.01p
Mn724 n724 n723 0 0 NMOD W=10u L=1u
Mp724 n724 n723 vdd vdd PMOD W=20u L=1u
CL724 n724 0 0.01p
Mn725 n725 n724 0 0 NMOD W=10u L=1u
Mp725 n725 n724 vdd vdd PMOD W=20u L=1u
CL725 n725 0 0.01p
Mn726 n726 n725 0 0 NMOD W=10u L=1u
Mp726 n726 n725 vdd vdd PMOD W=20u L=1u
CL726 n726 0 0.01p
Mn727 n727 n726 0 0 NMOD W=10u L=1u
Mp727 n727 n726 vdd vdd PMOD W=20u L=1u
CL727 n727 0 0.01p
Mn728 n728 n727 0 0 NMOD W=10u L=1u
Mp728 n728 n727 vdd vdd PMOD W=20u L=1u
CL728 n728 0 0.01p
Mn729 n729 n728 0 0 NMOD W=10u L=1u
Mp729 n729 n728 vdd vdd PMOD W=20u L=1u
CL729 n729 0 0.01p
Mn730 n730 n729 0 0 NMOD W=10u L=1u
Mp730 n730 n729 vdd vdd PMOD W=20u L=1u
CL730 n730 0 0.01p
Mn731 n731 n730 0 0 NMOD W=10u L=1u
Mp731 n731 n730 vdd vdd PMOD W=20u L=1u
CL731 n731 0 0.01p
Mn732 n732 n731 0 0 NMOD W=10u L=1u
Mp732 n732 n731 vdd vdd PMOD W=20u L=1u
CL732 n732 0 0.01p
Mn733 n733 n732 0 0 NMOD W=10u L=1u
Mp733 n733 n732 vdd vdd PMOD W=20u L=1u
CL733 n733 0 0.01p
Mn734 n734 n733 0 0 NMOD W=10u L=1u
Mp734 n734 n733 vdd vdd PMOD W=20u L=1u
CL734 n734 0 0.01p
Mn735 n735 n734 0 0 NMOD W=10u L=1u
Mp735 n735 n734 vdd vdd PMOD W=20u L=1u
CL735 n735 0 0.01p
Mn736 n736 n735 0 0 NMOD W=10u L=1u
Mp736 n736 n735 vdd vdd PMOD W=20u L=1u
CL736 n736 0 0.01p
Mn737 n737 n736 0 0 NMOD W=10u L=1u
Mp737 n737 n736 vdd vdd PMOD W=20u L=1u
CL737 n737 0 0.01p
Mn738 n738 n737 0 0 NMOD W=10u L=1u
Mp738 n738 n737 vdd vdd PMOD W=20u L=1u
CL738 n738 0 0.01p
Mn739 n739 n738 0 0 NMOD W=10u L=1u
Mp739 n739 n738 vdd vdd PMOD W=20u L=1u
CL739 n739 0 0.01p
Mn740 n740 n739 0 0 NMOD W=10u L=1u
Mp740 n740 n739 vdd vdd PMOD W=20u L=1u
CL740 n740 0 0.01p
Mn741 n741 n740 0 0 NMOD W=10u L=1u
Mp741 n741 n740 vdd vdd PMOD W=20u L=1u
CL741 n741 0 0.01p
Mn742 n742 n741 0 0 NMOD W=10u L=1u
Mp742 n742 n741 vdd vdd PMOD W=20u L=1u
CL742 n742 0 0.01p
Mn743 n743 n742 0 0 NMOD W=10u L=1u
Mp743 n743 n742 vdd vdd PMOD W=20u L=1u
CL743 n743 0 0.01p
Mn744 n744 n743 0 0 NMOD W=10u L=1u
Mp744 n744 n743 vdd vdd PMOD W=20u L=1u
CL744 n744 0 0.01p
Mn745 n745 n744 0 0 NMOD W=10u L=1u
Mp745 n745 n744 vdd vdd PMOD W=20u L=1u
CL745 n745 0 0.01p
Mn746 n746 n745 0 0 NMOD W=10u L=1u
Mp746 n746 n745 vdd vdd PMOD W=20u L=1u
CL746 n746 0 0.01p
Mn747 n747 n746 0 0 NMOD W=10u L=1u
Mp747 n747 n746 vdd vdd PMOD W=20u L=1u
CL747 n747 0 0.01p
Mn748 n748 n747 0 0 NMOD W=10u L=1u
Mp748 n748 n747 vdd vdd PMOD W=20u L=1u
CL748 n748 0 0.01p
Mn749 n749 n748 0 0 NMOD W=10u L=1u
Mp749 n749 n748 vdd vdd PMOD W=20u L=1u
CL749 n749 0 0.01p
Mn750 n750 n749 0 0 NMOD W=10u L=1u
Mp750 n750 n749 vdd vdd PMOD W=20u L=1u
CL750 n750 0 0.01p
Mn751 n751 n750 0 0 NMOD W=10u L=1u
Mp751 n751 n750 vdd vdd PMOD W=20u L=1u
CL751 n751 0 0.01p
Mn752 n752 n751 0 0 NMOD W=10u L=1u
Mp752 n752 n751 vdd vdd PMOD W=20u L=1u
CL752 n752 0 0.01p
Mn753 n753 n752 0 0 NMOD W=10u L=1u
Mp753 n753 n752 vdd vdd PMOD W=20u L=1u
CL753 n753 0 0.01p
Mn754 n754 n753 0 0 NMOD W=10u L=1u
Mp754 n754 n753 vdd vdd PMOD W=20u L=1u
CL754 n754 0 0.01p
Mn755 n755 n754 0 0 NMOD W=10u L=1u
Mp755 n755 n754 vdd vdd PMOD W=20u L=1u
CL755 n755 0 0.01p
Mn756 n756 n755 0 0 NMOD W=10u L=1u
Mp756 n756 n755 vdd vdd PMOD W=20u L=1u
CL756 n756 0 0.01p
Mn757 n757 n756 0 0 NMOD W=10u L=1u
Mp757 n757 n756 vdd vdd PMOD W=20u L=1u
CL757 n757 0 0.01p
Mn758 n758 n757 0 0 NMOD W=10u L=1u
Mp758 n758 n757 vdd vdd PMOD W=20u L=1u
CL758 n758 0 0.01p
Mn759 n759 n758 0 0 NMOD W=10u L=1u
Mp759 n759 n758 vdd vdd PMOD W=20u L=1u
CL759 n759 0 0.01p
Mn760 n760 n759 0 0 NMOD W=10u L=1u
Mp760 n760 n759 vdd vdd PMOD W=20u L=1u
CL760 n760 0 0.01p
Mn761 n761 n760 0 0 NMOD W=10u L=1u
Mp761 n761 n760 vdd vdd PMOD W=20u L=1u
CL761 n761 0 0.01p
Mn762 n762 n761 0 0 NMOD W=10u L=1u
Mp762 n762 n761 vdd vdd PMOD W=20u L=1u
CL762 n762 0 0.01p
Mn763 n763 n762 0 0 NMOD W=10u L=1u
Mp763 n763 n762 vdd vdd PMOD W=20u L=1u
CL763 n763 0 0.01p
Mn764 n764 n763 0 0 NMOD W=10u L=1u
Mp764 n764 n763 vdd vdd PMOD W=20u L=1u
CL764 n764 0 0.01p
Mn765 n765 n764 0 0 NMOD W=10u L=1u
Mp765 n765 n764 vdd vdd PMOD W=20u L=1u
CL765 n765 0 0.01p
Mn766 n766 n765 0 0 NMOD W=10u L=1u
Mp766 n766 n765 vdd vdd PMOD W=20u L=1u
CL766 n766 0 0.01p
Mn767 n767 n766 0 0 NMOD W=10u L=1u
Mp767 n767 n766 vdd vdd PMOD W=20u L=1u
CL767 n767 0 0.01p
Mn768 n768 n767 0 0 NMOD W=10u L=1u
Mp768 n768 n767 vdd vdd PMOD W=20u L=1u
CL768 n768 0 0.01p
Mn769 n769 n768 0 0 NMOD W=10u L=1u
Mp769 n769 n768 vdd vdd PMOD W=20u L=1u
CL769 n769 0 0.01p
Mn770 n770 n769 0 0 NMOD W=10u L=1u
Mp770 n770 n769 vdd vdd PMOD W=20u L=1u
CL770 n770 0 0.01p
Mn771 n771 n770 0 0 NMOD W=10u L=1u
Mp771 n771 n770 vdd vdd PMOD W=20u L=1u
CL771 n771 0 0.01p
Mn772 n772 n771 0 0 NMOD W=10u L=1u
Mp772 n772 n771 vdd vdd PMOD W=20u L=1u
CL772 n772 0 0.01p
Mn773 n773 n772 0 0 NMOD W=10u L=1u
Mp773 n773 n772 vdd vdd PMOD W=20u L=1u
CL773 n773 0 0.01p
Mn774 n774 n773 0 0 NMOD W=10u L=1u
Mp774 n774 n773 vdd vdd PMOD W=20u L=1u
CL774 n774 0 0.01p
Mn775 n775 n774 0 0 NMOD W=10u L=1u
Mp775 n775 n774 vdd vdd PMOD W=20u L=1u
CL775 n775 0 0.01p
Mn776 n776 n775 0 0 NMOD W=10u L=1u
Mp776 n776 n775 vdd vdd PMOD W=20u L=1u
CL776 n776 0 0.01p
Mn777 n777 n776 0 0 NMOD W=10u L=1u
Mp777 n777 n776 vdd vdd PMOD W=20u L=1u
CL777 n777 0 0.01p
Mn778 n778 n777 0 0 NMOD W=10u L=1u
Mp778 n778 n777 vdd vdd PMOD W=20u L=1u
CL778 n778 0 0.01p
Mn779 n779 n778 0 0 NMOD W=10u L=1u
Mp779 n779 n778 vdd vdd PMOD W=20u L=1u
CL779 n779 0 0.01p
Mn780 n780 n779 0 0 NMOD W=10u L=1u
Mp780 n780 n779 vdd vdd PMOD W=20u L=1u
CL780 n780 0 0.01p
Mn781 n781 n780 0 0 NMOD W=10u L=1u
Mp781 n781 n780 vdd vdd PMOD W=20u L=1u
CL781 n781 0 0.01p
Mn782 n782 n781 0 0 NMOD W=10u L=1u
Mp782 n782 n781 vdd vdd PMOD W=20u L=1u
CL782 n782 0 0.01p
Mn783 n783 n782 0 0 NMOD W=10u L=1u
Mp783 n783 n782 vdd vdd PMOD W=20u L=1u
CL783 n783 0 0.01p
Mn784 n784 n783 0 0 NMOD W=10u L=1u
Mp784 n784 n783 vdd vdd PMOD W=20u L=1u
CL784 n784 0 0.01p
Mn785 n785 n784 0 0 NMOD W=10u L=1u
Mp785 n785 n784 vdd vdd PMOD W=20u L=1u
CL785 n785 0 0.01p
Mn786 n786 n785 0 0 NMOD W=10u L=1u
Mp786 n786 n785 vdd vdd PMOD W=20u L=1u
CL786 n786 0 0.01p
Mn787 n787 n786 0 0 NMOD W=10u L=1u
Mp787 n787 n786 vdd vdd PMOD W=20u L=1u
CL787 n787 0 0.01p
Mn788 n788 n787 0 0 NMOD W=10u L=1u
Mp788 n788 n787 vdd vdd PMOD W=20u L=1u
CL788 n788 0 0.01p
Mn789 n789 n788 0 0 NMOD W=10u L=1u
Mp789 n789 n788 vdd vdd PMOD W=20u L=1u
CL789 n789 0 0.01p
Mn790 n790 n789 0 0 NMOD W=10u L=1u
Mp790 n790 n789 vdd vdd PMOD W=20u L=1u
CL790 n790 0 0.01p
Mn791 n791 n790 0 0 NMOD W=10u L=1u
Mp791 n791 n790 vdd vdd PMOD W=20u L=1u
CL791 n791 0 0.01p
Mn792 n792 n791 0 0 NMOD W=10u L=1u
Mp792 n792 n791 vdd vdd PMOD W=20u L=1u
CL792 n792 0 0.01p
Mn793 n793 n792 0 0 NMOD W=10u L=1u
Mp793 n793 n792 vdd vdd PMOD W=20u L=1u
CL793 n793 0 0.01p
Mn794 n794 n793 0 0 NMOD W=10u L=1u
Mp794 n794 n793 vdd vdd PMOD W=20u L=1u
CL794 n794 0 0.01p
Mn795 n795 n794 0 0 NMOD W=10u L=1u
Mp795 n795 n794 vdd vdd PMOD W=20u L=1u
CL795 n795 0 0.01p
Mn796 n796 n795 0 0 NMOD W=10u L=1u
Mp796 n796 n795 vdd vdd PMOD W=20u L=1u
CL796 n796 0 0.01p
Mn797 n797 n796 0 0 NMOD W=10u L=1u
Mp797 n797 n796 vdd vdd PMOD W=20u L=1u
CL797 n797 0 0.01p
Mn798 n798 n797 0 0 NMOD W=10u L=1u
Mp798 n798 n797 vdd vdd PMOD W=20u L=1u
CL798 n798 0 0.01p
Mn799 n799 n798 0 0 NMOD W=10u L=1u
Mp799 n799 n798 vdd vdd PMOD W=20u L=1u
CL799 n799 0 0.01p
Mn800 n800 n799 0 0 NMOD W=10u L=1u
Mp800 n800 n799 vdd vdd PMOD W=20u L=1u
CL800 n800 0 0.01p
Mn801 n801 n800 0 0 NMOD W=10u L=1u
Mp801 n801 n800 vdd vdd PMOD W=20u L=1u
CL801 n801 0 0.01p
Mn802 n802 n801 0 0 NMOD W=10u L=1u
Mp802 n802 n801 vdd vdd PMOD W=20u L=1u
CL802 n802 0 0.01p
Mn803 n803 n802 0 0 NMOD W=10u L=1u
Mp803 n803 n802 vdd vdd PMOD W=20u L=1u
CL803 n803 0 0.01p
Mn804 n804 n803 0 0 NMOD W=10u L=1u
Mp804 n804 n803 vdd vdd PMOD W=20u L=1u
CL804 n804 0 0.01p
Mn805 n805 n804 0 0 NMOD W=10u L=1u
Mp805 n805 n804 vdd vdd PMOD W=20u L=1u
CL805 n805 0 0.01p
Mn806 n806 n805 0 0 NMOD W=10u L=1u
Mp806 n806 n805 vdd vdd PMOD W=20u L=1u
CL806 n806 0 0.01p
Mn807 n807 n806 0 0 NMOD W=10u L=1u
Mp807 n807 n806 vdd vdd PMOD W=20u L=1u
CL807 n807 0 0.01p
Mn808 n808 n807 0 0 NMOD W=10u L=1u
Mp808 n808 n807 vdd vdd PMOD W=20u L=1u
CL808 n808 0 0.01p
Mn809 n809 n808 0 0 NMOD W=10u L=1u
Mp809 n809 n808 vdd vdd PMOD W=20u L=1u
CL809 n809 0 0.01p
Mn810 n810 n809 0 0 NMOD W=10u L=1u
Mp810 n810 n809 vdd vdd PMOD W=20u L=1u
CL810 n810 0 0.01p
Mn811 n811 n810 0 0 NMOD W=10u L=1u
Mp811 n811 n810 vdd vdd PMOD W=20u L=1u
CL811 n811 0 0.01p
Mn812 n812 n811 0 0 NMOD W=10u L=1u
Mp812 n812 n811 vdd vdd PMOD W=20u L=1u
CL812 n812 0 0.01p
Mn813 n813 n812 0 0 NMOD W=10u L=1u
Mp813 n813 n812 vdd vdd PMOD W=20u L=1u
CL813 n813 0 0.01p
Mn814 n814 n813 0 0 NMOD W=10u L=1u
Mp814 n814 n813 vdd vdd PMOD W=20u L=1u
CL814 n814 0 0.01p
Mn815 n815 n814 0 0 NMOD W=10u L=1u
Mp815 n815 n814 vdd vdd PMOD W=20u L=1u
CL815 n815 0 0.01p
Mn816 n816 n815 0 0 NMOD W=10u L=1u
Mp816 n816 n815 vdd vdd PMOD W=20u L=1u
CL816 n816 0 0.01p
Mn817 n817 n816 0 0 NMOD W=10u L=1u
Mp817 n817 n816 vdd vdd PMOD W=20u L=1u
CL817 n817 0 0.01p
Mn818 n818 n817 0 0 NMOD W=10u L=1u
Mp818 n818 n817 vdd vdd PMOD W=20u L=1u
CL818 n818 0 0.01p
Mn819 n819 n818 0 0 NMOD W=10u L=1u
Mp819 n819 n818 vdd vdd PMOD W=20u L=1u
CL819 n819 0 0.01p
Mn820 n820 n819 0 0 NMOD W=10u L=1u
Mp820 n820 n819 vdd vdd PMOD W=20u L=1u
CL820 n820 0 0.01p
Mn821 n821 n820 0 0 NMOD W=10u L=1u
Mp821 n821 n820 vdd vdd PMOD W=20u L=1u
CL821 n821 0 0.01p
Mn822 n822 n821 0 0 NMOD W=10u L=1u
Mp822 n822 n821 vdd vdd PMOD W=20u L=1u
CL822 n822 0 0.01p
Mn823 n823 n822 0 0 NMOD W=10u L=1u
Mp823 n823 n822 vdd vdd PMOD W=20u L=1u
CL823 n823 0 0.01p
Mn824 n824 n823 0 0 NMOD W=10u L=1u
Mp824 n824 n823 vdd vdd PMOD W=20u L=1u
CL824 n824 0 0.01p
Mn825 n825 n824 0 0 NMOD W=10u L=1u
Mp825 n825 n824 vdd vdd PMOD W=20u L=1u
CL825 n825 0 0.01p
Mn826 n826 n825 0 0 NMOD W=10u L=1u
Mp826 n826 n825 vdd vdd PMOD W=20u L=1u
CL826 n826 0 0.01p
Mn827 n827 n826 0 0 NMOD W=10u L=1u
Mp827 n827 n826 vdd vdd PMOD W=20u L=1u
CL827 n827 0 0.01p
Mn828 n828 n827 0 0 NMOD W=10u L=1u
Mp828 n828 n827 vdd vdd PMOD W=20u L=1u
CL828 n828 0 0.01p
Mn829 n829 n828 0 0 NMOD W=10u L=1u
Mp829 n829 n828 vdd vdd PMOD W=20u L=1u
CL829 n829 0 0.01p
Mn830 n830 n829 0 0 NMOD W=10u L=1u
Mp830 n830 n829 vdd vdd PMOD W=20u L=1u
CL830 n830 0 0.01p
Mn831 n831 n830 0 0 NMOD W=10u L=1u
Mp831 n831 n830 vdd vdd PMOD W=20u L=1u
CL831 n831 0 0.01p
Mn832 n832 n831 0 0 NMOD W=10u L=1u
Mp832 n832 n831 vdd vdd PMOD W=20u L=1u
CL832 n832 0 0.01p
Mn833 n833 n832 0 0 NMOD W=10u L=1u
Mp833 n833 n832 vdd vdd PMOD W=20u L=1u
CL833 n833 0 0.01p
Mn834 n834 n833 0 0 NMOD W=10u L=1u
Mp834 n834 n833 vdd vdd PMOD W=20u L=1u
CL834 n834 0 0.01p
Mn835 n835 n834 0 0 NMOD W=10u L=1u
Mp835 n835 n834 vdd vdd PMOD W=20u L=1u
CL835 n835 0 0.01p
Mn836 n836 n835 0 0 NMOD W=10u L=1u
Mp836 n836 n835 vdd vdd PMOD W=20u L=1u
CL836 n836 0 0.01p
Mn837 n837 n836 0 0 NMOD W=10u L=1u
Mp837 n837 n836 vdd vdd PMOD W=20u L=1u
CL837 n837 0 0.01p
Mn838 n838 n837 0 0 NMOD W=10u L=1u
Mp838 n838 n837 vdd vdd PMOD W=20u L=1u
CL838 n838 0 0.01p
Mn839 n839 n838 0 0 NMOD W=10u L=1u
Mp839 n839 n838 vdd vdd PMOD W=20u L=1u
CL839 n839 0 0.01p
Mn840 n840 n839 0 0 NMOD W=10u L=1u
Mp840 n840 n839 vdd vdd PMOD W=20u L=1u
CL840 n840 0 0.01p
Mn841 n841 n840 0 0 NMOD W=10u L=1u
Mp841 n841 n840 vdd vdd PMOD W=20u L=1u
CL841 n841 0 0.01p
Mn842 n842 n841 0 0 NMOD W=10u L=1u
Mp842 n842 n841 vdd vdd PMOD W=20u L=1u
CL842 n842 0 0.01p
Mn843 n843 n842 0 0 NMOD W=10u L=1u
Mp843 n843 n842 vdd vdd PMOD W=20u L=1u
CL843 n843 0 0.01p
Mn844 n844 n843 0 0 NMOD W=10u L=1u
Mp844 n844 n843 vdd vdd PMOD W=20u L=1u
CL844 n844 0 0.01p
Mn845 n845 n844 0 0 NMOD W=10u L=1u
Mp845 n845 n844 vdd vdd PMOD W=20u L=1u
CL845 n845 0 0.01p
Mn846 n846 n845 0 0 NMOD W=10u L=1u
Mp846 n846 n845 vdd vdd PMOD W=20u L=1u
CL846 n846 0 0.01p
Mn847 n847 n846 0 0 NMOD W=10u L=1u
Mp847 n847 n846 vdd vdd PMOD W=20u L=1u
CL847 n847 0 0.01p
Mn848 n848 n847 0 0 NMOD W=10u L=1u
Mp848 n848 n847 vdd vdd PMOD W=20u L=1u
CL848 n848 0 0.01p
Mn849 n849 n848 0 0 NMOD W=10u L=1u
Mp849 n849 n848 vdd vdd PMOD W=20u L=1u
CL849 n849 0 0.01p
Mn850 n850 n849 0 0 NMOD W=10u L=1u
Mp850 n850 n849 vdd vdd PMOD W=20u L=1u
CL850 n850 0 0.01p
Mn851 n851 n850 0 0 NMOD W=10u L=1u
Mp851 n851 n850 vdd vdd PMOD W=20u L=1u
CL851 n851 0 0.01p
Mn852 n852 n851 0 0 NMOD W=10u L=1u
Mp852 n852 n851 vdd vdd PMOD W=20u L=1u
CL852 n852 0 0.01p
Mn853 n853 n852 0 0 NMOD W=10u L=1u
Mp853 n853 n852 vdd vdd PMOD W=20u L=1u
CL853 n853 0 0.01p
Mn854 n854 n853 0 0 NMOD W=10u L=1u
Mp854 n854 n853 vdd vdd PMOD W=20u L=1u
CL854 n854 0 0.01p
Mn855 n855 n854 0 0 NMOD W=10u L=1u
Mp855 n855 n854 vdd vdd PMOD W=20u L=1u
CL855 n855 0 0.01p
Mn856 n856 n855 0 0 NMOD W=10u L=1u
Mp856 n856 n855 vdd vdd PMOD W=20u L=1u
CL856 n856 0 0.01p
Mn857 n857 n856 0 0 NMOD W=10u L=1u
Mp857 n857 n856 vdd vdd PMOD W=20u L=1u
CL857 n857 0 0.01p
Mn858 n858 n857 0 0 NMOD W=10u L=1u
Mp858 n858 n857 vdd vdd PMOD W=20u L=1u
CL858 n858 0 0.01p
Mn859 n859 n858 0 0 NMOD W=10u L=1u
Mp859 n859 n858 vdd vdd PMOD W=20u L=1u
CL859 n859 0 0.01p
Mn860 n860 n859 0 0 NMOD W=10u L=1u
Mp860 n860 n859 vdd vdd PMOD W=20u L=1u
CL860 n860 0 0.01p
Mn861 n861 n860 0 0 NMOD W=10u L=1u
Mp861 n861 n860 vdd vdd PMOD W=20u L=1u
CL861 n861 0 0.01p
Mn862 n862 n861 0 0 NMOD W=10u L=1u
Mp862 n862 n861 vdd vdd PMOD W=20u L=1u
CL862 n862 0 0.01p
Mn863 n863 n862 0 0 NMOD W=10u L=1u
Mp863 n863 n862 vdd vdd PMOD W=20u L=1u
CL863 n863 0 0.01p
Mn864 n864 n863 0 0 NMOD W=10u L=1u
Mp864 n864 n863 vdd vdd PMOD W=20u L=1u
CL864 n864 0 0.01p
Mn865 n865 n864 0 0 NMOD W=10u L=1u
Mp865 n865 n864 vdd vdd PMOD W=20u L=1u
CL865 n865 0 0.01p
Mn866 n866 n865 0 0 NMOD W=10u L=1u
Mp866 n866 n865 vdd vdd PMOD W=20u L=1u
CL866 n866 0 0.01p
Mn867 n867 n866 0 0 NMOD W=10u L=1u
Mp867 n867 n866 vdd vdd PMOD W=20u L=1u
CL867 n867 0 0.01p
Mn868 n868 n867 0 0 NMOD W=10u L=1u
Mp868 n868 n867 vdd vdd PMOD W=20u L=1u
CL868 n868 0 0.01p
Mn869 n869 n868 0 0 NMOD W=10u L=1u
Mp869 n869 n868 vdd vdd PMOD W=20u L=1u
CL869 n869 0 0.01p
Mn870 n870 n869 0 0 NMOD W=10u L=1u
Mp870 n870 n869 vdd vdd PMOD W=20u L=1u
CL870 n870 0 0.01p
Mn871 n871 n870 0 0 NMOD W=10u L=1u
Mp871 n871 n870 vdd vdd PMOD W=20u L=1u
CL871 n871 0 0.01p
Mn872 n872 n871 0 0 NMOD W=10u L=1u
Mp872 n872 n871 vdd vdd PMOD W=20u L=1u
CL872 n872 0 0.01p
Mn873 n873 n872 0 0 NMOD W=10u L=1u
Mp873 n873 n872 vdd vdd PMOD W=20u L=1u
CL873 n873 0 0.01p
Mn874 n874 n873 0 0 NMOD W=10u L=1u
Mp874 n874 n873 vdd vdd PMOD W=20u L=1u
CL874 n874 0 0.01p
Mn875 n875 n874 0 0 NMOD W=10u L=1u
Mp875 n875 n874 vdd vdd PMOD W=20u L=1u
CL875 n875 0 0.01p
Mn876 n876 n875 0 0 NMOD W=10u L=1u
Mp876 n876 n875 vdd vdd PMOD W=20u L=1u
CL876 n876 0 0.01p
Mn877 n877 n876 0 0 NMOD W=10u L=1u
Mp877 n877 n876 vdd vdd PMOD W=20u L=1u
CL877 n877 0 0.01p
Mn878 n878 n877 0 0 NMOD W=10u L=1u
Mp878 n878 n877 vdd vdd PMOD W=20u L=1u
CL878 n878 0 0.01p
Mn879 n879 n878 0 0 NMOD W=10u L=1u
Mp879 n879 n878 vdd vdd PMOD W=20u L=1u
CL879 n879 0 0.01p
Mn880 n880 n879 0 0 NMOD W=10u L=1u
Mp880 n880 n879 vdd vdd PMOD W=20u L=1u
CL880 n880 0 0.01p
Mn881 n881 n880 0 0 NMOD W=10u L=1u
Mp881 n881 n880 vdd vdd PMOD W=20u L=1u
CL881 n881 0 0.01p
Mn882 n882 n881 0 0 NMOD W=10u L=1u
Mp882 n882 n881 vdd vdd PMOD W=20u L=1u
CL882 n882 0 0.01p
Mn883 n883 n882 0 0 NMOD W=10u L=1u
Mp883 n883 n882 vdd vdd PMOD W=20u L=1u
CL883 n883 0 0.01p
Mn884 n884 n883 0 0 NMOD W=10u L=1u
Mp884 n884 n883 vdd vdd PMOD W=20u L=1u
CL884 n884 0 0.01p
Mn885 n885 n884 0 0 NMOD W=10u L=1u
Mp885 n885 n884 vdd vdd PMOD W=20u L=1u
CL885 n885 0 0.01p
Mn886 n886 n885 0 0 NMOD W=10u L=1u
Mp886 n886 n885 vdd vdd PMOD W=20u L=1u
CL886 n886 0 0.01p
Mn887 n887 n886 0 0 NMOD W=10u L=1u
Mp887 n887 n886 vdd vdd PMOD W=20u L=1u
CL887 n887 0 0.01p
Mn888 n888 n887 0 0 NMOD W=10u L=1u
Mp888 n888 n887 vdd vdd PMOD W=20u L=1u
CL888 n888 0 0.01p
Mn889 n889 n888 0 0 NMOD W=10u L=1u
Mp889 n889 n888 vdd vdd PMOD W=20u L=1u
CL889 n889 0 0.01p
Mn890 n890 n889 0 0 NMOD W=10u L=1u
Mp890 n890 n889 vdd vdd PMOD W=20u L=1u
CL890 n890 0 0.01p
Mn891 n891 n890 0 0 NMOD W=10u L=1u
Mp891 n891 n890 vdd vdd PMOD W=20u L=1u
CL891 n891 0 0.01p
Mn892 n892 n891 0 0 NMOD W=10u L=1u
Mp892 n892 n891 vdd vdd PMOD W=20u L=1u
CL892 n892 0 0.01p
Mn893 n893 n892 0 0 NMOD W=10u L=1u
Mp893 n893 n892 vdd vdd PMOD W=20u L=1u
CL893 n893 0 0.01p
Mn894 n894 n893 0 0 NMOD W=10u L=1u
Mp894 n894 n893 vdd vdd PMOD W=20u L=1u
CL894 n894 0 0.01p
Mn895 n895 n894 0 0 NMOD W=10u L=1u
Mp895 n895 n894 vdd vdd PMOD W=20u L=1u
CL895 n895 0 0.01p
Mn896 n896 n895 0 0 NMOD W=10u L=1u
Mp896 n896 n895 vdd vdd PMOD W=20u L=1u
CL896 n896 0 0.01p
Mn897 n897 n896 0 0 NMOD W=10u L=1u
Mp897 n897 n896 vdd vdd PMOD W=20u L=1u
CL897 n897 0 0.01p
Mn898 n898 n897 0 0 NMOD W=10u L=1u
Mp898 n898 n897 vdd vdd PMOD W=20u L=1u
CL898 n898 0 0.01p
Mn899 n899 n898 0 0 NMOD W=10u L=1u
Mp899 n899 n898 vdd vdd PMOD W=20u L=1u
CL899 n899 0 0.01p
Mn900 n900 n899 0 0 NMOD W=10u L=1u
Mp900 n900 n899 vdd vdd PMOD W=20u L=1u
CL900 n900 0 0.01p
Mn901 n901 n900 0 0 NMOD W=10u L=1u
Mp901 n901 n900 vdd vdd PMOD W=20u L=1u
CL901 n901 0 0.01p
Mn902 n902 n901 0 0 NMOD W=10u L=1u
Mp902 n902 n901 vdd vdd PMOD W=20u L=1u
CL902 n902 0 0.01p
Mn903 n903 n902 0 0 NMOD W=10u L=1u
Mp903 n903 n902 vdd vdd PMOD W=20u L=1u
CL903 n903 0 0.01p
Mn904 n904 n903 0 0 NMOD W=10u L=1u
Mp904 n904 n903 vdd vdd PMOD W=20u L=1u
CL904 n904 0 0.01p
Mn905 n905 n904 0 0 NMOD W=10u L=1u
Mp905 n905 n904 vdd vdd PMOD W=20u L=1u
CL905 n905 0 0.01p
Mn906 n906 n905 0 0 NMOD W=10u L=1u
Mp906 n906 n905 vdd vdd PMOD W=20u L=1u
CL906 n906 0 0.01p
Mn907 n907 n906 0 0 NMOD W=10u L=1u
Mp907 n907 n906 vdd vdd PMOD W=20u L=1u
CL907 n907 0 0.01p
Mn908 n908 n907 0 0 NMOD W=10u L=1u
Mp908 n908 n907 vdd vdd PMOD W=20u L=1u
CL908 n908 0 0.01p
Mn909 n909 n908 0 0 NMOD W=10u L=1u
Mp909 n909 n908 vdd vdd PMOD W=20u L=1u
CL909 n909 0 0.01p
Mn910 n910 n909 0 0 NMOD W=10u L=1u
Mp910 n910 n909 vdd vdd PMOD W=20u L=1u
CL910 n910 0 0.01p
Mn911 n911 n910 0 0 NMOD W=10u L=1u
Mp911 n911 n910 vdd vdd PMOD W=20u L=1u
CL911 n911 0 0.01p
Mn912 n912 n911 0 0 NMOD W=10u L=1u
Mp912 n912 n911 vdd vdd PMOD W=20u L=1u
CL912 n912 0 0.01p
Mn913 n913 n912 0 0 NMOD W=10u L=1u
Mp913 n913 n912 vdd vdd PMOD W=20u L=1u
CL913 n913 0 0.01p
Mn914 n914 n913 0 0 NMOD W=10u L=1u
Mp914 n914 n913 vdd vdd PMOD W=20u L=1u
CL914 n914 0 0.01p
Mn915 n915 n914 0 0 NMOD W=10u L=1u
Mp915 n915 n914 vdd vdd PMOD W=20u L=1u
CL915 n915 0 0.01p
Mn916 n916 n915 0 0 NMOD W=10u L=1u
Mp916 n916 n915 vdd vdd PMOD W=20u L=1u
CL916 n916 0 0.01p
Mn917 n917 n916 0 0 NMOD W=10u L=1u
Mp917 n917 n916 vdd vdd PMOD W=20u L=1u
CL917 n917 0 0.01p
Mn918 n918 n917 0 0 NMOD W=10u L=1u
Mp918 n918 n917 vdd vdd PMOD W=20u L=1u
CL918 n918 0 0.01p
Mn919 n919 n918 0 0 NMOD W=10u L=1u
Mp919 n919 n918 vdd vdd PMOD W=20u L=1u
CL919 n919 0 0.01p
Mn920 n920 n919 0 0 NMOD W=10u L=1u
Mp920 n920 n919 vdd vdd PMOD W=20u L=1u
CL920 n920 0 0.01p
Mn921 n921 n920 0 0 NMOD W=10u L=1u
Mp921 n921 n920 vdd vdd PMOD W=20u L=1u
CL921 n921 0 0.01p
Mn922 n922 n921 0 0 NMOD W=10u L=1u
Mp922 n922 n921 vdd vdd PMOD W=20u L=1u
CL922 n922 0 0.01p
Mn923 n923 n922 0 0 NMOD W=10u L=1u
Mp923 n923 n922 vdd vdd PMOD W=20u L=1u
CL923 n923 0 0.01p
Mn924 n924 n923 0 0 NMOD W=10u L=1u
Mp924 n924 n923 vdd vdd PMOD W=20u L=1u
CL924 n924 0 0.01p
Mn925 n925 n924 0 0 NMOD W=10u L=1u
Mp925 n925 n924 vdd vdd PMOD W=20u L=1u
CL925 n925 0 0.01p
Mn926 n926 n925 0 0 NMOD W=10u L=1u
Mp926 n926 n925 vdd vdd PMOD W=20u L=1u
CL926 n926 0 0.01p
Mn927 n927 n926 0 0 NMOD W=10u L=1u
Mp927 n927 n926 vdd vdd PMOD W=20u L=1u
CL927 n927 0 0.01p
Mn928 n928 n927 0 0 NMOD W=10u L=1u
Mp928 n928 n927 vdd vdd PMOD W=20u L=1u
CL928 n928 0 0.01p
Mn929 n929 n928 0 0 NMOD W=10u L=1u
Mp929 n929 n928 vdd vdd PMOD W=20u L=1u
CL929 n929 0 0.01p
Mn930 n930 n929 0 0 NMOD W=10u L=1u
Mp930 n930 n929 vdd vdd PMOD W=20u L=1u
CL930 n930 0 0.01p
Mn931 n931 n930 0 0 NMOD W=10u L=1u
Mp931 n931 n930 vdd vdd PMOD W=20u L=1u
CL931 n931 0 0.01p
Mn932 n932 n931 0 0 NMOD W=10u L=1u
Mp932 n932 n931 vdd vdd PMOD W=20u L=1u
CL932 n932 0 0.01p
Mn933 n933 n932 0 0 NMOD W=10u L=1u
Mp933 n933 n932 vdd vdd PMOD W=20u L=1u
CL933 n933 0 0.01p
Mn934 n934 n933 0 0 NMOD W=10u L=1u
Mp934 n934 n933 vdd vdd PMOD W=20u L=1u
CL934 n934 0 0.01p
Mn935 n935 n934 0 0 NMOD W=10u L=1u
Mp935 n935 n934 vdd vdd PMOD W=20u L=1u
CL935 n935 0 0.01p
Mn936 n936 n935 0 0 NMOD W=10u L=1u
Mp936 n936 n935 vdd vdd PMOD W=20u L=1u
CL936 n936 0 0.01p
Mn937 n937 n936 0 0 NMOD W=10u L=1u
Mp937 n937 n936 vdd vdd PMOD W=20u L=1u
CL937 n937 0 0.01p
Mn938 n938 n937 0 0 NMOD W=10u L=1u
Mp938 n938 n937 vdd vdd PMOD W=20u L=1u
CL938 n938 0 0.01p
Mn939 n939 n938 0 0 NMOD W=10u L=1u
Mp939 n939 n938 vdd vdd PMOD W=20u L=1u
CL939 n939 0 0.01p
Mn940 n940 n939 0 0 NMOD W=10u L=1u
Mp940 n940 n939 vdd vdd PMOD W=20u L=1u
CL940 n940 0 0.01p
Mn941 n941 n940 0 0 NMOD W=10u L=1u
Mp941 n941 n940 vdd vdd PMOD W=20u L=1u
CL941 n941 0 0.01p
Mn942 n942 n941 0 0 NMOD W=10u L=1u
Mp942 n942 n941 vdd vdd PMOD W=20u L=1u
CL942 n942 0 0.01p
Mn943 n943 n942 0 0 NMOD W=10u L=1u
Mp943 n943 n942 vdd vdd PMOD W=20u L=1u
CL943 n943 0 0.01p
Mn944 n944 n943 0 0 NMOD W=10u L=1u
Mp944 n944 n943 vdd vdd PMOD W=20u L=1u
CL944 n944 0 0.01p
Mn945 n945 n944 0 0 NMOD W=10u L=1u
Mp945 n945 n944 vdd vdd PMOD W=20u L=1u
CL945 n945 0 0.01p
Mn946 n946 n945 0 0 NMOD W=10u L=1u
Mp946 n946 n945 vdd vdd PMOD W=20u L=1u
CL946 n946 0 0.01p
Mn947 n947 n946 0 0 NMOD W=10u L=1u
Mp947 n947 n946 vdd vdd PMOD W=20u L=1u
CL947 n947 0 0.01p
Mn948 n948 n947 0 0 NMOD W=10u L=1u
Mp948 n948 n947 vdd vdd PMOD W=20u L=1u
CL948 n948 0 0.01p
Mn949 n949 n948 0 0 NMOD W=10u L=1u
Mp949 n949 n948 vdd vdd PMOD W=20u L=1u
CL949 n949 0 0.01p
Mn950 n950 n949 0 0 NMOD W=10u L=1u
Mp950 n950 n949 vdd vdd PMOD W=20u L=1u
CL950 n950 0 0.01p
Mn951 n951 n950 0 0 NMOD W=10u L=1u
Mp951 n951 n950 vdd vdd PMOD W=20u L=1u
CL951 n951 0 0.01p
Mn952 n952 n951 0 0 NMOD W=10u L=1u
Mp952 n952 n951 vdd vdd PMOD W=20u L=1u
CL952 n952 0 0.01p
Mn953 n953 n952 0 0 NMOD W=10u L=1u
Mp953 n953 n952 vdd vdd PMOD W=20u L=1u
CL953 n953 0 0.01p
Mn954 n954 n953 0 0 NMOD W=10u L=1u
Mp954 n954 n953 vdd vdd PMOD W=20u L=1u
CL954 n954 0 0.01p
Mn955 n955 n954 0 0 NMOD W=10u L=1u
Mp955 n955 n954 vdd vdd PMOD W=20u L=1u
CL955 n955 0 0.01p
Mn956 n956 n955 0 0 NMOD W=10u L=1u
Mp956 n956 n955 vdd vdd PMOD W=20u L=1u
CL956 n956 0 0.01p
Mn957 n957 n956 0 0 NMOD W=10u L=1u
Mp957 n957 n956 vdd vdd PMOD W=20u L=1u
CL957 n957 0 0.01p
Mn958 n958 n957 0 0 NMOD W=10u L=1u
Mp958 n958 n957 vdd vdd PMOD W=20u L=1u
CL958 n958 0 0.01p
Mn959 n959 n958 0 0 NMOD W=10u L=1u
Mp959 n959 n958 vdd vdd PMOD W=20u L=1u
CL959 n959 0 0.01p
Mn960 n960 n959 0 0 NMOD W=10u L=1u
Mp960 n960 n959 vdd vdd PMOD W=20u L=1u
CL960 n960 0 0.01p
Mn961 n961 n960 0 0 NMOD W=10u L=1u
Mp961 n961 n960 vdd vdd PMOD W=20u L=1u
CL961 n961 0 0.01p
Mn962 n962 n961 0 0 NMOD W=10u L=1u
Mp962 n962 n961 vdd vdd PMOD W=20u L=1u
CL962 n962 0 0.01p
Mn963 n963 n962 0 0 NMOD W=10u L=1u
Mp963 n963 n962 vdd vdd PMOD W=20u L=1u
CL963 n963 0 0.01p
Mn964 n964 n963 0 0 NMOD W=10u L=1u
Mp964 n964 n963 vdd vdd PMOD W=20u L=1u
CL964 n964 0 0.01p
Mn965 n965 n964 0 0 NMOD W=10u L=1u
Mp965 n965 n964 vdd vdd PMOD W=20u L=1u
CL965 n965 0 0.01p
Mn966 n966 n965 0 0 NMOD W=10u L=1u
Mp966 n966 n965 vdd vdd PMOD W=20u L=1u
CL966 n966 0 0.01p
Mn967 n967 n966 0 0 NMOD W=10u L=1u
Mp967 n967 n966 vdd vdd PMOD W=20u L=1u
CL967 n967 0 0.01p
Mn968 n968 n967 0 0 NMOD W=10u L=1u
Mp968 n968 n967 vdd vdd PMOD W=20u L=1u
CL968 n968 0 0.01p
Mn969 n969 n968 0 0 NMOD W=10u L=1u
Mp969 n969 n968 vdd vdd PMOD W=20u L=1u
CL969 n969 0 0.01p
Mn970 n970 n969 0 0 NMOD W=10u L=1u
Mp970 n970 n969 vdd vdd PMOD W=20u L=1u
CL970 n970 0 0.01p
Mn971 n971 n970 0 0 NMOD W=10u L=1u
Mp971 n971 n970 vdd vdd PMOD W=20u L=1u
CL971 n971 0 0.01p
Mn972 n972 n971 0 0 NMOD W=10u L=1u
Mp972 n972 n971 vdd vdd PMOD W=20u L=1u
CL972 n972 0 0.01p
Mn973 n973 n972 0 0 NMOD W=10u L=1u
Mp973 n973 n972 vdd vdd PMOD W=20u L=1u
CL973 n973 0 0.01p
Mn974 n974 n973 0 0 NMOD W=10u L=1u
Mp974 n974 n973 vdd vdd PMOD W=20u L=1u
CL974 n974 0 0.01p
Mn975 n975 n974 0 0 NMOD W=10u L=1u
Mp975 n975 n974 vdd vdd PMOD W=20u L=1u
CL975 n975 0 0.01p
Mn976 n976 n975 0 0 NMOD W=10u L=1u
Mp976 n976 n975 vdd vdd PMOD W=20u L=1u
CL976 n976 0 0.01p
Mn977 n977 n976 0 0 NMOD W=10u L=1u
Mp977 n977 n976 vdd vdd PMOD W=20u L=1u
CL977 n977 0 0.01p
Mn978 n978 n977 0 0 NMOD W=10u L=1u
Mp978 n978 n977 vdd vdd PMOD W=20u L=1u
CL978 n978 0 0.01p
Mn979 n979 n978 0 0 NMOD W=10u L=1u
Mp979 n979 n978 vdd vdd PMOD W=20u L=1u
CL979 n979 0 0.01p
Mn980 n980 n979 0 0 NMOD W=10u L=1u
Mp980 n980 n979 vdd vdd PMOD W=20u L=1u
CL980 n980 0 0.01p
Mn981 n981 n980 0 0 NMOD W=10u L=1u
Mp981 n981 n980 vdd vdd PMOD W=20u L=1u
CL981 n981 0 0.01p
Mn982 n982 n981 0 0 NMOD W=10u L=1u
Mp982 n982 n981 vdd vdd PMOD W=20u L=1u
CL982 n982 0 0.01p
Mn983 n983 n982 0 0 NMOD W=10u L=1u
Mp983 n983 n982 vdd vdd PMOD W=20u L=1u
CL983 n983 0 0.01p
Mn984 n984 n983 0 0 NMOD W=10u L=1u
Mp984 n984 n983 vdd vdd PMOD W=20u L=1u
CL984 n984 0 0.01p
Mn985 n985 n984 0 0 NMOD W=10u L=1u
Mp985 n985 n984 vdd vdd PMOD W=20u L=1u
CL985 n985 0 0.01p
Mn986 n986 n985 0 0 NMOD W=10u L=1u
Mp986 n986 n985 vdd vdd PMOD W=20u L=1u
CL986 n986 0 0.01p
Mn987 n987 n986 0 0 NMOD W=10u L=1u
Mp987 n987 n986 vdd vdd PMOD W=20u L=1u
CL987 n987 0 0.01p
Mn988 n988 n987 0 0 NMOD W=10u L=1u
Mp988 n988 n987 vdd vdd PMOD W=20u L=1u
CL988 n988 0 0.01p
Mn989 n989 n988 0 0 NMOD W=10u L=1u
Mp989 n989 n988 vdd vdd PMOD W=20u L=1u
CL989 n989 0 0.01p
Mn990 n990 n989 0 0 NMOD W=10u L=1u
Mp990 n990 n989 vdd vdd PMOD W=20u L=1u
CL990 n990 0 0.01p
Mn991 n991 n990 0 0 NMOD W=10u L=1u
Mp991 n991 n990 vdd vdd PMOD W=20u L=1u
CL991 n991 0 0.01p
Mn992 n992 n991 0 0 NMOD W=10u L=1u
Mp992 n992 n991 vdd vdd PMOD W=20u L=1u
CL992 n992 0 0.01p
Mn993 n993 n992 0 0 NMOD W=10u L=1u
Mp993 n993 n992 vdd vdd PMOD W=20u L=1u
CL993 n993 0 0.01p
Mn994 n994 n993 0 0 NMOD W=10u L=1u
Mp994 n994 n993 vdd vdd PMOD W=20u L=1u
CL994 n994 0 0.01p
Mn995 n995 n994 0 0 NMOD W=10u L=1u
Mp995 n995 n994 vdd vdd PMOD W=20u L=1u
CL995 n995 0 0.01p
Mn996 n996 n995 0 0 NMOD W=10u L=1u
Mp996 n996 n995 vdd vdd PMOD W=20u L=1u
CL996 n996 0 0.01p
Mn997 n997 n996 0 0 NMOD W=10u L=1u
Mp997 n997 n996 vdd vdd PMOD W=20u L=1u
CL997 n997 0 0.01p
Mn998 n998 n997 0 0 NMOD W=10u L=1u
Mp998 n998 n997 vdd vdd PMOD W=20u L=1u
CL998 n998 0 0.01p
Mn999 n999 n998 0 0 NMOD W=10u L=1u
Mp999 n999 n998 vdd vdd PMOD W=20u L=1u
CL999 n999 0 0.01p
Mn1000 n1000 n999 0 0 NMOD W=10u L=1u
Mp1000 n1000 n999 vdd vdd PMOD W=20u L=1u
CL1000 n1000 0 0.01p

.TRAN 0.5n 200n
.END
