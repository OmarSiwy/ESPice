* RC Ladder — 100 stages
V1 1 0 PULSE(0 1 0 1n 1n 1u 2u)
R1 1 2 1k
R2 2 3 1k
R3 3 4 1k
R4 4 5 1k
R5 5 6 1k
R6 6 7 1k
R7 7 8 1k
R8 8 9 1k
R9 9 10 1k
R10 10 11 1k
R11 11 12 1k
R12 12 13 1k
R13 13 14 1k
R14 14 15 1k
R15 15 16 1k
R16 16 17 1k
R17 17 18 1k
R18 18 19 1k
R19 19 20 1k
R20 20 21 1k
R21 21 22 1k
R22 22 23 1k
R23 23 24 1k
R24 24 25 1k
R25 25 26 1k
R26 26 27 1k
R27 27 28 1k
R28 28 29 1k
R29 29 30 1k
R30 30 31 1k
R31 31 32 1k
R32 32 33 1k
R33 33 34 1k
R34 34 35 1k
R35 35 36 1k
R36 36 37 1k
R37 37 38 1k
R38 38 39 1k
R39 39 40 1k
R40 40 41 1k
R41 41 42 1k
R42 42 43 1k
R43 43 44 1k
R44 44 45 1k
R45 45 46 1k
R46 46 47 1k
R47 47 48 1k
R48 48 49 1k
R49 49 50 1k
R50 50 51 1k
R51 51 52 1k
R52 52 53 1k
R53 53 54 1k
R54 54 55 1k
R55 55 56 1k
R56 56 57 1k
R57 57 58 1k
R58 58 59 1k
R59 59 60 1k
R60 60 61 1k
R61 61 62 1k
R62 62 63 1k
R63 63 64 1k
R64 64 65 1k
R65 65 66 1k
R66 66 67 1k
R67 67 68 1k
R68 68 69 1k
R69 69 70 1k
R70 70 71 1k
R71 71 72 1k
R72 72 73 1k
R73 73 74 1k
R74 74 75 1k
R75 75 76 1k
R76 76 77 1k
R77 77 78 1k
R78 78 79 1k
R79 79 80 1k
R80 80 81 1k
R81 81 82 1k
R82 82 83 1k
R83 83 84 1k
R84 84 85 1k
R85 85 86 1k
R86 86 87 1k
R87 87 88 1k
R88 88 89 1k
R89 89 90 1k
R90 90 91 1k
R91 91 92 1k
R92 92 93 1k
R93 93 94 1k
R94 94 95 1k
R95 95 96 1k
R96 96 97 1k
R97 97 98 1k
R98 98 99 1k
R99 99 100 1k
R100 100 101 1k
C1 2 0 1p
C2 3 0 1p
C3 4 0 1p
C4 5 0 1p
C5 6 0 1p
C6 7 0 1p
C7 8 0 1p
C8 9 0 1p
C9 10 0 1p
C10 11 0 1p
C11 12 0 1p
C12 13 0 1p
C13 14 0 1p
C14 15 0 1p
C15 16 0 1p
C16 17 0 1p
C17 18 0 1p
C18 19 0 1p
C19 20 0 1p
C20 21 0 1p
C21 22 0 1p
C22 23 0 1p
C23 24 0 1p
C24 25 0 1p
C25 26 0 1p
C26 27 0 1p
C27 28 0 1p
C28 29 0 1p
C29 30 0 1p
C30 31 0 1p
C31 32 0 1p
C32 33 0 1p
C33 34 0 1p
C34 35 0 1p
C35 36 0 1p
C36 37 0 1p
C37 38 0 1p
C38 39 0 1p
C39 40 0 1p
C40 41 0 1p
C41 42 0 1p
C42 43 0 1p
C43 44 0 1p
C44 45 0 1p
C45 46 0 1p
C46 47 0 1p
C47 48 0 1p
C48 49 0 1p
C49 50 0 1p
C50 51 0 1p
C51 52 0 1p
C52 53 0 1p
C53 54 0 1p
C54 55 0 1p
C55 56 0 1p
C56 57 0 1p
C57 58 0 1p
C58 59 0 1p
C59 60 0 1p
C60 61 0 1p
C61 62 0 1p
C62 63 0 1p
C63 64 0 1p
C64 65 0 1p
C65 66 0 1p
C66 67 0 1p
C67 68 0 1p
C68 69 0 1p
C69 70 0 1p
C70 71 0 1p
C71 72 0 1p
C72 73 0 1p
C73 74 0 1p
C74 75 0 1p
C75 76 0 1p
C76 77 0 1p
C77 78 0 1p
C78 79 0 1p
C79 80 0 1p
C80 81 0 1p
C81 82 0 1p
C82 83 0 1p
C83 84 0 1p
C84 85 0 1p
C85 86 0 1p
C86 87 0 1p
C87 88 0 1p
C88 89 0 1p
C89 90 0 1p
C90 91 0 1p
C91 92 0 1p
C92 93 0 1p
C93 94 0 1p
C94 95 0 1p
C95 96 0 1p
C96 97 0 1p
C97 98 0 1p
C98 99 0 1p
C99 100 0 1p
C100 101 0 1p
.TRAN 0.1n 10u
.END
