* CMOS Inverter Chain — 500 stages
VDD vdd 0 DC 3.3
VIN in 0 PULSE(0 3.3 1n 0.5n 0.5n 10n 20n)

.MODEL NMOD NMOS (VTO=0.5 KP=120u)
.MODEL PMOD PMOS (VTO=-0.5 KP=60u)

Mn1 n1 in 0 0 NMOD W=10u L=1u
Mp1 n1 in vdd vdd PMOD W=20u L=1u
CL1 n1 0 0.01p
Mn2 n2 n1 0 0 NMOD W=10u L=1u
Mp2 n2 n1 vdd vdd PMOD W=20u L=1u
CL2 n2 0 0.01p
Mn3 n3 n2 0 0 NMOD W=10u L=1u
Mp3 n3 n2 vdd vdd PMOD W=20u L=1u
CL3 n3 0 0.01p
Mn4 n4 n3 0 0 NMOD W=10u L=1u
Mp4 n4 n3 vdd vdd PMOD W=20u L=1u
CL4 n4 0 0.01p
Mn5 n5 n4 0 0 NMOD W=10u L=1u
Mp5 n5 n4 vdd vdd PMOD W=20u L=1u
CL5 n5 0 0.01p
Mn6 n6 n5 0 0 NMOD W=10u L=1u
Mp6 n6 n5 vdd vdd PMOD W=20u L=1u
CL6 n6 0 0.01p
Mn7 n7 n6 0 0 NMOD W=10u L=1u
Mp7 n7 n6 vdd vdd PMOD W=20u L=1u
CL7 n7 0 0.01p
Mn8 n8 n7 0 0 NMOD W=10u L=1u
Mp8 n8 n7 vdd vdd PMOD W=20u L=1u
CL8 n8 0 0.01p
Mn9 n9 n8 0 0 NMOD W=10u L=1u
Mp9 n9 n8 vdd vdd PMOD W=20u L=1u
CL9 n9 0 0.01p
Mn10 n10 n9 0 0 NMOD W=10u L=1u
Mp10 n10 n9 vdd vdd PMOD W=20u L=1u
CL10 n10 0 0.01p
Mn11 n11 n10 0 0 NMOD W=10u L=1u
Mp11 n11 n10 vdd vdd PMOD W=20u L=1u
CL11 n11 0 0.01p
Mn12 n12 n11 0 0 NMOD W=10u L=1u
Mp12 n12 n11 vdd vdd PMOD W=20u L=1u
CL12 n12 0 0.01p
Mn13 n13 n12 0 0 NMOD W=10u L=1u
Mp13 n13 n12 vdd vdd PMOD W=20u L=1u
CL13 n13 0 0.01p
Mn14 n14 n13 0 0 NMOD W=10u L=1u
Mp14 n14 n13 vdd vdd PMOD W=20u L=1u
CL14 n14 0 0.01p
Mn15 n15 n14 0 0 NMOD W=10u L=1u
Mp15 n15 n14 vdd vdd PMOD W=20u L=1u
CL15 n15 0 0.01p
Mn16 n16 n15 0 0 NMOD W=10u L=1u
Mp16 n16 n15 vdd vdd PMOD W=20u L=1u
CL16 n16 0 0.01p
Mn17 n17 n16 0 0 NMOD W=10u L=1u
Mp17 n17 n16 vdd vdd PMOD W=20u L=1u
CL17 n17 0 0.01p
Mn18 n18 n17 0 0 NMOD W=10u L=1u
Mp18 n18 n17 vdd vdd PMOD W=20u L=1u
CL18 n18 0 0.01p
Mn19 n19 n18 0 0 NMOD W=10u L=1u
Mp19 n19 n18 vdd vdd PMOD W=20u L=1u
CL19 n19 0 0.01p
Mn20 n20 n19 0 0 NMOD W=10u L=1u
Mp20 n20 n19 vdd vdd PMOD W=20u L=1u
CL20 n20 0 0.01p
Mn21 n21 n20 0 0 NMOD W=10u L=1u
Mp21 n21 n20 vdd vdd PMOD W=20u L=1u
CL21 n21 0 0.01p
Mn22 n22 n21 0 0 NMOD W=10u L=1u
Mp22 n22 n21 vdd vdd PMOD W=20u L=1u
CL22 n22 0 0.01p
Mn23 n23 n22 0 0 NMOD W=10u L=1u
Mp23 n23 n22 vdd vdd PMOD W=20u L=1u
CL23 n23 0 0.01p
Mn24 n24 n23 0 0 NMOD W=10u L=1u
Mp24 n24 n23 vdd vdd PMOD W=20u L=1u
CL24 n24 0 0.01p
Mn25 n25 n24 0 0 NMOD W=10u L=1u
Mp25 n25 n24 vdd vdd PMOD W=20u L=1u
CL25 n25 0 0.01p
Mn26 n26 n25 0 0 NMOD W=10u L=1u
Mp26 n26 n25 vdd vdd PMOD W=20u L=1u
CL26 n26 0 0.01p
Mn27 n27 n26 0 0 NMOD W=10u L=1u
Mp27 n27 n26 vdd vdd PMOD W=20u L=1u
CL27 n27 0 0.01p
Mn28 n28 n27 0 0 NMOD W=10u L=1u
Mp28 n28 n27 vdd vdd PMOD W=20u L=1u
CL28 n28 0 0.01p
Mn29 n29 n28 0 0 NMOD W=10u L=1u
Mp29 n29 n28 vdd vdd PMOD W=20u L=1u
CL29 n29 0 0.01p
Mn30 n30 n29 0 0 NMOD W=10u L=1u
Mp30 n30 n29 vdd vdd PMOD W=20u L=1u
CL30 n30 0 0.01p
Mn31 n31 n30 0 0 NMOD W=10u L=1u
Mp31 n31 n30 vdd vdd PMOD W=20u L=1u
CL31 n31 0 0.01p
Mn32 n32 n31 0 0 NMOD W=10u L=1u
Mp32 n32 n31 vdd vdd PMOD W=20u L=1u
CL32 n32 0 0.01p
Mn33 n33 n32 0 0 NMOD W=10u L=1u
Mp33 n33 n32 vdd vdd PMOD W=20u L=1u
CL33 n33 0 0.01p
Mn34 n34 n33 0 0 NMOD W=10u L=1u
Mp34 n34 n33 vdd vdd PMOD W=20u L=1u
CL34 n34 0 0.01p
Mn35 n35 n34 0 0 NMOD W=10u L=1u
Mp35 n35 n34 vdd vdd PMOD W=20u L=1u
CL35 n35 0 0.01p
Mn36 n36 n35 0 0 NMOD W=10u L=1u
Mp36 n36 n35 vdd vdd PMOD W=20u L=1u
CL36 n36 0 0.01p
Mn37 n37 n36 0 0 NMOD W=10u L=1u
Mp37 n37 n36 vdd vdd PMOD W=20u L=1u
CL37 n37 0 0.01p
Mn38 n38 n37 0 0 NMOD W=10u L=1u
Mp38 n38 n37 vdd vdd PMOD W=20u L=1u
CL38 n38 0 0.01p
Mn39 n39 n38 0 0 NMOD W=10u L=1u
Mp39 n39 n38 vdd vdd PMOD W=20u L=1u
CL39 n39 0 0.01p
Mn40 n40 n39 0 0 NMOD W=10u L=1u
Mp40 n40 n39 vdd vdd PMOD W=20u L=1u
CL40 n40 0 0.01p
Mn41 n41 n40 0 0 NMOD W=10u L=1u
Mp41 n41 n40 vdd vdd PMOD W=20u L=1u
CL41 n41 0 0.01p
Mn42 n42 n41 0 0 NMOD W=10u L=1u
Mp42 n42 n41 vdd vdd PMOD W=20u L=1u
CL42 n42 0 0.01p
Mn43 n43 n42 0 0 NMOD W=10u L=1u
Mp43 n43 n42 vdd vdd PMOD W=20u L=1u
CL43 n43 0 0.01p
Mn44 n44 n43 0 0 NMOD W=10u L=1u
Mp44 n44 n43 vdd vdd PMOD W=20u L=1u
CL44 n44 0 0.01p
Mn45 n45 n44 0 0 NMOD W=10u L=1u
Mp45 n45 n44 vdd vdd PMOD W=20u L=1u
CL45 n45 0 0.01p
Mn46 n46 n45 0 0 NMOD W=10u L=1u
Mp46 n46 n45 vdd vdd PMOD W=20u L=1u
CL46 n46 0 0.01p
Mn47 n47 n46 0 0 NMOD W=10u L=1u
Mp47 n47 n46 vdd vdd PMOD W=20u L=1u
CL47 n47 0 0.01p
Mn48 n48 n47 0 0 NMOD W=10u L=1u
Mp48 n48 n47 vdd vdd PMOD W=20u L=1u
CL48 n48 0 0.01p
Mn49 n49 n48 0 0 NMOD W=10u L=1u
Mp49 n49 n48 vdd vdd PMOD W=20u L=1u
CL49 n49 0 0.01p
Mn50 n50 n49 0 0 NMOD W=10u L=1u
Mp50 n50 n49 vdd vdd PMOD W=20u L=1u
CL50 n50 0 0.01p
Mn51 n51 n50 0 0 NMOD W=10u L=1u
Mp51 n51 n50 vdd vdd PMOD W=20u L=1u
CL51 n51 0 0.01p
Mn52 n52 n51 0 0 NMOD W=10u L=1u
Mp52 n52 n51 vdd vdd PMOD W=20u L=1u
CL52 n52 0 0.01p
Mn53 n53 n52 0 0 NMOD W=10u L=1u
Mp53 n53 n52 vdd vdd PMOD W=20u L=1u
CL53 n53 0 0.01p
Mn54 n54 n53 0 0 NMOD W=10u L=1u
Mp54 n54 n53 vdd vdd PMOD W=20u L=1u
CL54 n54 0 0.01p
Mn55 n55 n54 0 0 NMOD W=10u L=1u
Mp55 n55 n54 vdd vdd PMOD W=20u L=1u
CL55 n55 0 0.01p
Mn56 n56 n55 0 0 NMOD W=10u L=1u
Mp56 n56 n55 vdd vdd PMOD W=20u L=1u
CL56 n56 0 0.01p
Mn57 n57 n56 0 0 NMOD W=10u L=1u
Mp57 n57 n56 vdd vdd PMOD W=20u L=1u
CL57 n57 0 0.01p
Mn58 n58 n57 0 0 NMOD W=10u L=1u
Mp58 n58 n57 vdd vdd PMOD W=20u L=1u
CL58 n58 0 0.01p
Mn59 n59 n58 0 0 NMOD W=10u L=1u
Mp59 n59 n58 vdd vdd PMOD W=20u L=1u
CL59 n59 0 0.01p
Mn60 n60 n59 0 0 NMOD W=10u L=1u
Mp60 n60 n59 vdd vdd PMOD W=20u L=1u
CL60 n60 0 0.01p
Mn61 n61 n60 0 0 NMOD W=10u L=1u
Mp61 n61 n60 vdd vdd PMOD W=20u L=1u
CL61 n61 0 0.01p
Mn62 n62 n61 0 0 NMOD W=10u L=1u
Mp62 n62 n61 vdd vdd PMOD W=20u L=1u
CL62 n62 0 0.01p
Mn63 n63 n62 0 0 NMOD W=10u L=1u
Mp63 n63 n62 vdd vdd PMOD W=20u L=1u
CL63 n63 0 0.01p
Mn64 n64 n63 0 0 NMOD W=10u L=1u
Mp64 n64 n63 vdd vdd PMOD W=20u L=1u
CL64 n64 0 0.01p
Mn65 n65 n64 0 0 NMOD W=10u L=1u
Mp65 n65 n64 vdd vdd PMOD W=20u L=1u
CL65 n65 0 0.01p
Mn66 n66 n65 0 0 NMOD W=10u L=1u
Mp66 n66 n65 vdd vdd PMOD W=20u L=1u
CL66 n66 0 0.01p
Mn67 n67 n66 0 0 NMOD W=10u L=1u
Mp67 n67 n66 vdd vdd PMOD W=20u L=1u
CL67 n67 0 0.01p
Mn68 n68 n67 0 0 NMOD W=10u L=1u
Mp68 n68 n67 vdd vdd PMOD W=20u L=1u
CL68 n68 0 0.01p
Mn69 n69 n68 0 0 NMOD W=10u L=1u
Mp69 n69 n68 vdd vdd PMOD W=20u L=1u
CL69 n69 0 0.01p
Mn70 n70 n69 0 0 NMOD W=10u L=1u
Mp70 n70 n69 vdd vdd PMOD W=20u L=1u
CL70 n70 0 0.01p
Mn71 n71 n70 0 0 NMOD W=10u L=1u
Mp71 n71 n70 vdd vdd PMOD W=20u L=1u
CL71 n71 0 0.01p
Mn72 n72 n71 0 0 NMOD W=10u L=1u
Mp72 n72 n71 vdd vdd PMOD W=20u L=1u
CL72 n72 0 0.01p
Mn73 n73 n72 0 0 NMOD W=10u L=1u
Mp73 n73 n72 vdd vdd PMOD W=20u L=1u
CL73 n73 0 0.01p
Mn74 n74 n73 0 0 NMOD W=10u L=1u
Mp74 n74 n73 vdd vdd PMOD W=20u L=1u
CL74 n74 0 0.01p
Mn75 n75 n74 0 0 NMOD W=10u L=1u
Mp75 n75 n74 vdd vdd PMOD W=20u L=1u
CL75 n75 0 0.01p
Mn76 n76 n75 0 0 NMOD W=10u L=1u
Mp76 n76 n75 vdd vdd PMOD W=20u L=1u
CL76 n76 0 0.01p
Mn77 n77 n76 0 0 NMOD W=10u L=1u
Mp77 n77 n76 vdd vdd PMOD W=20u L=1u
CL77 n77 0 0.01p
Mn78 n78 n77 0 0 NMOD W=10u L=1u
Mp78 n78 n77 vdd vdd PMOD W=20u L=1u
CL78 n78 0 0.01p
Mn79 n79 n78 0 0 NMOD W=10u L=1u
Mp79 n79 n78 vdd vdd PMOD W=20u L=1u
CL79 n79 0 0.01p
Mn80 n80 n79 0 0 NMOD W=10u L=1u
Mp80 n80 n79 vdd vdd PMOD W=20u L=1u
CL80 n80 0 0.01p
Mn81 n81 n80 0 0 NMOD W=10u L=1u
Mp81 n81 n80 vdd vdd PMOD W=20u L=1u
CL81 n81 0 0.01p
Mn82 n82 n81 0 0 NMOD W=10u L=1u
Mp82 n82 n81 vdd vdd PMOD W=20u L=1u
CL82 n82 0 0.01p
Mn83 n83 n82 0 0 NMOD W=10u L=1u
Mp83 n83 n82 vdd vdd PMOD W=20u L=1u
CL83 n83 0 0.01p
Mn84 n84 n83 0 0 NMOD W=10u L=1u
Mp84 n84 n83 vdd vdd PMOD W=20u L=1u
CL84 n84 0 0.01p
Mn85 n85 n84 0 0 NMOD W=10u L=1u
Mp85 n85 n84 vdd vdd PMOD W=20u L=1u
CL85 n85 0 0.01p
Mn86 n86 n85 0 0 NMOD W=10u L=1u
Mp86 n86 n85 vdd vdd PMOD W=20u L=1u
CL86 n86 0 0.01p
Mn87 n87 n86 0 0 NMOD W=10u L=1u
Mp87 n87 n86 vdd vdd PMOD W=20u L=1u
CL87 n87 0 0.01p
Mn88 n88 n87 0 0 NMOD W=10u L=1u
Mp88 n88 n87 vdd vdd PMOD W=20u L=1u
CL88 n88 0 0.01p
Mn89 n89 n88 0 0 NMOD W=10u L=1u
Mp89 n89 n88 vdd vdd PMOD W=20u L=1u
CL89 n89 0 0.01p
Mn90 n90 n89 0 0 NMOD W=10u L=1u
Mp90 n90 n89 vdd vdd PMOD W=20u L=1u
CL90 n90 0 0.01p
Mn91 n91 n90 0 0 NMOD W=10u L=1u
Mp91 n91 n90 vdd vdd PMOD W=20u L=1u
CL91 n91 0 0.01p
Mn92 n92 n91 0 0 NMOD W=10u L=1u
Mp92 n92 n91 vdd vdd PMOD W=20u L=1u
CL92 n92 0 0.01p
Mn93 n93 n92 0 0 NMOD W=10u L=1u
Mp93 n93 n92 vdd vdd PMOD W=20u L=1u
CL93 n93 0 0.01p
Mn94 n94 n93 0 0 NMOD W=10u L=1u
Mp94 n94 n93 vdd vdd PMOD W=20u L=1u
CL94 n94 0 0.01p
Mn95 n95 n94 0 0 NMOD W=10u L=1u
Mp95 n95 n94 vdd vdd PMOD W=20u L=1u
CL95 n95 0 0.01p
Mn96 n96 n95 0 0 NMOD W=10u L=1u
Mp96 n96 n95 vdd vdd PMOD W=20u L=1u
CL96 n96 0 0.01p
Mn97 n97 n96 0 0 NMOD W=10u L=1u
Mp97 n97 n96 vdd vdd PMOD W=20u L=1u
CL97 n97 0 0.01p
Mn98 n98 n97 0 0 NMOD W=10u L=1u
Mp98 n98 n97 vdd vdd PMOD W=20u L=1u
CL98 n98 0 0.01p
Mn99 n99 n98 0 0 NMOD W=10u L=1u
Mp99 n99 n98 vdd vdd PMOD W=20u L=1u
CL99 n99 0 0.01p
Mn100 n100 n99 0 0 NMOD W=10u L=1u
Mp100 n100 n99 vdd vdd PMOD W=20u L=1u
CL100 n100 0 0.01p
Mn101 n101 n100 0 0 NMOD W=10u L=1u
Mp101 n101 n100 vdd vdd PMOD W=20u L=1u
CL101 n101 0 0.01p
Mn102 n102 n101 0 0 NMOD W=10u L=1u
Mp102 n102 n101 vdd vdd PMOD W=20u L=1u
CL102 n102 0 0.01p
Mn103 n103 n102 0 0 NMOD W=10u L=1u
Mp103 n103 n102 vdd vdd PMOD W=20u L=1u
CL103 n103 0 0.01p
Mn104 n104 n103 0 0 NMOD W=10u L=1u
Mp104 n104 n103 vdd vdd PMOD W=20u L=1u
CL104 n104 0 0.01p
Mn105 n105 n104 0 0 NMOD W=10u L=1u
Mp105 n105 n104 vdd vdd PMOD W=20u L=1u
CL105 n105 0 0.01p
Mn106 n106 n105 0 0 NMOD W=10u L=1u
Mp106 n106 n105 vdd vdd PMOD W=20u L=1u
CL106 n106 0 0.01p
Mn107 n107 n106 0 0 NMOD W=10u L=1u
Mp107 n107 n106 vdd vdd PMOD W=20u L=1u
CL107 n107 0 0.01p
Mn108 n108 n107 0 0 NMOD W=10u L=1u
Mp108 n108 n107 vdd vdd PMOD W=20u L=1u
CL108 n108 0 0.01p
Mn109 n109 n108 0 0 NMOD W=10u L=1u
Mp109 n109 n108 vdd vdd PMOD W=20u L=1u
CL109 n109 0 0.01p
Mn110 n110 n109 0 0 NMOD W=10u L=1u
Mp110 n110 n109 vdd vdd PMOD W=20u L=1u
CL110 n110 0 0.01p
Mn111 n111 n110 0 0 NMOD W=10u L=1u
Mp111 n111 n110 vdd vdd PMOD W=20u L=1u
CL111 n111 0 0.01p
Mn112 n112 n111 0 0 NMOD W=10u L=1u
Mp112 n112 n111 vdd vdd PMOD W=20u L=1u
CL112 n112 0 0.01p
Mn113 n113 n112 0 0 NMOD W=10u L=1u
Mp113 n113 n112 vdd vdd PMOD W=20u L=1u
CL113 n113 0 0.01p
Mn114 n114 n113 0 0 NMOD W=10u L=1u
Mp114 n114 n113 vdd vdd PMOD W=20u L=1u
CL114 n114 0 0.01p
Mn115 n115 n114 0 0 NMOD W=10u L=1u
Mp115 n115 n114 vdd vdd PMOD W=20u L=1u
CL115 n115 0 0.01p
Mn116 n116 n115 0 0 NMOD W=10u L=1u
Mp116 n116 n115 vdd vdd PMOD W=20u L=1u
CL116 n116 0 0.01p
Mn117 n117 n116 0 0 NMOD W=10u L=1u
Mp117 n117 n116 vdd vdd PMOD W=20u L=1u
CL117 n117 0 0.01p
Mn118 n118 n117 0 0 NMOD W=10u L=1u
Mp118 n118 n117 vdd vdd PMOD W=20u L=1u
CL118 n118 0 0.01p
Mn119 n119 n118 0 0 NMOD W=10u L=1u
Mp119 n119 n118 vdd vdd PMOD W=20u L=1u
CL119 n119 0 0.01p
Mn120 n120 n119 0 0 NMOD W=10u L=1u
Mp120 n120 n119 vdd vdd PMOD W=20u L=1u
CL120 n120 0 0.01p
Mn121 n121 n120 0 0 NMOD W=10u L=1u
Mp121 n121 n120 vdd vdd PMOD W=20u L=1u
CL121 n121 0 0.01p
Mn122 n122 n121 0 0 NMOD W=10u L=1u
Mp122 n122 n121 vdd vdd PMOD W=20u L=1u
CL122 n122 0 0.01p
Mn123 n123 n122 0 0 NMOD W=10u L=1u
Mp123 n123 n122 vdd vdd PMOD W=20u L=1u
CL123 n123 0 0.01p
Mn124 n124 n123 0 0 NMOD W=10u L=1u
Mp124 n124 n123 vdd vdd PMOD W=20u L=1u
CL124 n124 0 0.01p
Mn125 n125 n124 0 0 NMOD W=10u L=1u
Mp125 n125 n124 vdd vdd PMOD W=20u L=1u
CL125 n125 0 0.01p
Mn126 n126 n125 0 0 NMOD W=10u L=1u
Mp126 n126 n125 vdd vdd PMOD W=20u L=1u
CL126 n126 0 0.01p
Mn127 n127 n126 0 0 NMOD W=10u L=1u
Mp127 n127 n126 vdd vdd PMOD W=20u L=1u
CL127 n127 0 0.01p
Mn128 n128 n127 0 0 NMOD W=10u L=1u
Mp128 n128 n127 vdd vdd PMOD W=20u L=1u
CL128 n128 0 0.01p
Mn129 n129 n128 0 0 NMOD W=10u L=1u
Mp129 n129 n128 vdd vdd PMOD W=20u L=1u
CL129 n129 0 0.01p
Mn130 n130 n129 0 0 NMOD W=10u L=1u
Mp130 n130 n129 vdd vdd PMOD W=20u L=1u
CL130 n130 0 0.01p
Mn131 n131 n130 0 0 NMOD W=10u L=1u
Mp131 n131 n130 vdd vdd PMOD W=20u L=1u
CL131 n131 0 0.01p
Mn132 n132 n131 0 0 NMOD W=10u L=1u
Mp132 n132 n131 vdd vdd PMOD W=20u L=1u
CL132 n132 0 0.01p
Mn133 n133 n132 0 0 NMOD W=10u L=1u
Mp133 n133 n132 vdd vdd PMOD W=20u L=1u
CL133 n133 0 0.01p
Mn134 n134 n133 0 0 NMOD W=10u L=1u
Mp134 n134 n133 vdd vdd PMOD W=20u L=1u
CL134 n134 0 0.01p
Mn135 n135 n134 0 0 NMOD W=10u L=1u
Mp135 n135 n134 vdd vdd PMOD W=20u L=1u
CL135 n135 0 0.01p
Mn136 n136 n135 0 0 NMOD W=10u L=1u
Mp136 n136 n135 vdd vdd PMOD W=20u L=1u
CL136 n136 0 0.01p
Mn137 n137 n136 0 0 NMOD W=10u L=1u
Mp137 n137 n136 vdd vdd PMOD W=20u L=1u
CL137 n137 0 0.01p
Mn138 n138 n137 0 0 NMOD W=10u L=1u
Mp138 n138 n137 vdd vdd PMOD W=20u L=1u
CL138 n138 0 0.01p
Mn139 n139 n138 0 0 NMOD W=10u L=1u
Mp139 n139 n138 vdd vdd PMOD W=20u L=1u
CL139 n139 0 0.01p
Mn140 n140 n139 0 0 NMOD W=10u L=1u
Mp140 n140 n139 vdd vdd PMOD W=20u L=1u
CL140 n140 0 0.01p
Mn141 n141 n140 0 0 NMOD W=10u L=1u
Mp141 n141 n140 vdd vdd PMOD W=20u L=1u
CL141 n141 0 0.01p
Mn142 n142 n141 0 0 NMOD W=10u L=1u
Mp142 n142 n141 vdd vdd PMOD W=20u L=1u
CL142 n142 0 0.01p
Mn143 n143 n142 0 0 NMOD W=10u L=1u
Mp143 n143 n142 vdd vdd PMOD W=20u L=1u
CL143 n143 0 0.01p
Mn144 n144 n143 0 0 NMOD W=10u L=1u
Mp144 n144 n143 vdd vdd PMOD W=20u L=1u
CL144 n144 0 0.01p
Mn145 n145 n144 0 0 NMOD W=10u L=1u
Mp145 n145 n144 vdd vdd PMOD W=20u L=1u
CL145 n145 0 0.01p
Mn146 n146 n145 0 0 NMOD W=10u L=1u
Mp146 n146 n145 vdd vdd PMOD W=20u L=1u
CL146 n146 0 0.01p
Mn147 n147 n146 0 0 NMOD W=10u L=1u
Mp147 n147 n146 vdd vdd PMOD W=20u L=1u
CL147 n147 0 0.01p
Mn148 n148 n147 0 0 NMOD W=10u L=1u
Mp148 n148 n147 vdd vdd PMOD W=20u L=1u
CL148 n148 0 0.01p
Mn149 n149 n148 0 0 NMOD W=10u L=1u
Mp149 n149 n148 vdd vdd PMOD W=20u L=1u
CL149 n149 0 0.01p
Mn150 n150 n149 0 0 NMOD W=10u L=1u
Mp150 n150 n149 vdd vdd PMOD W=20u L=1u
CL150 n150 0 0.01p
Mn151 n151 n150 0 0 NMOD W=10u L=1u
Mp151 n151 n150 vdd vdd PMOD W=20u L=1u
CL151 n151 0 0.01p
Mn152 n152 n151 0 0 NMOD W=10u L=1u
Mp152 n152 n151 vdd vdd PMOD W=20u L=1u
CL152 n152 0 0.01p
Mn153 n153 n152 0 0 NMOD W=10u L=1u
Mp153 n153 n152 vdd vdd PMOD W=20u L=1u
CL153 n153 0 0.01p
Mn154 n154 n153 0 0 NMOD W=10u L=1u
Mp154 n154 n153 vdd vdd PMOD W=20u L=1u
CL154 n154 0 0.01p
Mn155 n155 n154 0 0 NMOD W=10u L=1u
Mp155 n155 n154 vdd vdd PMOD W=20u L=1u
CL155 n155 0 0.01p
Mn156 n156 n155 0 0 NMOD W=10u L=1u
Mp156 n156 n155 vdd vdd PMOD W=20u L=1u
CL156 n156 0 0.01p
Mn157 n157 n156 0 0 NMOD W=10u L=1u
Mp157 n157 n156 vdd vdd PMOD W=20u L=1u
CL157 n157 0 0.01p
Mn158 n158 n157 0 0 NMOD W=10u L=1u
Mp158 n158 n157 vdd vdd PMOD W=20u L=1u
CL158 n158 0 0.01p
Mn159 n159 n158 0 0 NMOD W=10u L=1u
Mp159 n159 n158 vdd vdd PMOD W=20u L=1u
CL159 n159 0 0.01p
Mn160 n160 n159 0 0 NMOD W=10u L=1u
Mp160 n160 n159 vdd vdd PMOD W=20u L=1u
CL160 n160 0 0.01p
Mn161 n161 n160 0 0 NMOD W=10u L=1u
Mp161 n161 n160 vdd vdd PMOD W=20u L=1u
CL161 n161 0 0.01p
Mn162 n162 n161 0 0 NMOD W=10u L=1u
Mp162 n162 n161 vdd vdd PMOD W=20u L=1u
CL162 n162 0 0.01p
Mn163 n163 n162 0 0 NMOD W=10u L=1u
Mp163 n163 n162 vdd vdd PMOD W=20u L=1u
CL163 n163 0 0.01p
Mn164 n164 n163 0 0 NMOD W=10u L=1u
Mp164 n164 n163 vdd vdd PMOD W=20u L=1u
CL164 n164 0 0.01p
Mn165 n165 n164 0 0 NMOD W=10u L=1u
Mp165 n165 n164 vdd vdd PMOD W=20u L=1u
CL165 n165 0 0.01p
Mn166 n166 n165 0 0 NMOD W=10u L=1u
Mp166 n166 n165 vdd vdd PMOD W=20u L=1u
CL166 n166 0 0.01p
Mn167 n167 n166 0 0 NMOD W=10u L=1u
Mp167 n167 n166 vdd vdd PMOD W=20u L=1u
CL167 n167 0 0.01p
Mn168 n168 n167 0 0 NMOD W=10u L=1u
Mp168 n168 n167 vdd vdd PMOD W=20u L=1u
CL168 n168 0 0.01p
Mn169 n169 n168 0 0 NMOD W=10u L=1u
Mp169 n169 n168 vdd vdd PMOD W=20u L=1u
CL169 n169 0 0.01p
Mn170 n170 n169 0 0 NMOD W=10u L=1u
Mp170 n170 n169 vdd vdd PMOD W=20u L=1u
CL170 n170 0 0.01p
Mn171 n171 n170 0 0 NMOD W=10u L=1u
Mp171 n171 n170 vdd vdd PMOD W=20u L=1u
CL171 n171 0 0.01p
Mn172 n172 n171 0 0 NMOD W=10u L=1u
Mp172 n172 n171 vdd vdd PMOD W=20u L=1u
CL172 n172 0 0.01p
Mn173 n173 n172 0 0 NMOD W=10u L=1u
Mp173 n173 n172 vdd vdd PMOD W=20u L=1u
CL173 n173 0 0.01p
Mn174 n174 n173 0 0 NMOD W=10u L=1u
Mp174 n174 n173 vdd vdd PMOD W=20u L=1u
CL174 n174 0 0.01p
Mn175 n175 n174 0 0 NMOD W=10u L=1u
Mp175 n175 n174 vdd vdd PMOD W=20u L=1u
CL175 n175 0 0.01p
Mn176 n176 n175 0 0 NMOD W=10u L=1u
Mp176 n176 n175 vdd vdd PMOD W=20u L=1u
CL176 n176 0 0.01p
Mn177 n177 n176 0 0 NMOD W=10u L=1u
Mp177 n177 n176 vdd vdd PMOD W=20u L=1u
CL177 n177 0 0.01p
Mn178 n178 n177 0 0 NMOD W=10u L=1u
Mp178 n178 n177 vdd vdd PMOD W=20u L=1u
CL178 n178 0 0.01p
Mn179 n179 n178 0 0 NMOD W=10u L=1u
Mp179 n179 n178 vdd vdd PMOD W=20u L=1u
CL179 n179 0 0.01p
Mn180 n180 n179 0 0 NMOD W=10u L=1u
Mp180 n180 n179 vdd vdd PMOD W=20u L=1u
CL180 n180 0 0.01p
Mn181 n181 n180 0 0 NMOD W=10u L=1u
Mp181 n181 n180 vdd vdd PMOD W=20u L=1u
CL181 n181 0 0.01p
Mn182 n182 n181 0 0 NMOD W=10u L=1u
Mp182 n182 n181 vdd vdd PMOD W=20u L=1u
CL182 n182 0 0.01p
Mn183 n183 n182 0 0 NMOD W=10u L=1u
Mp183 n183 n182 vdd vdd PMOD W=20u L=1u
CL183 n183 0 0.01p
Mn184 n184 n183 0 0 NMOD W=10u L=1u
Mp184 n184 n183 vdd vdd PMOD W=20u L=1u
CL184 n184 0 0.01p
Mn185 n185 n184 0 0 NMOD W=10u L=1u
Mp185 n185 n184 vdd vdd PMOD W=20u L=1u
CL185 n185 0 0.01p
Mn186 n186 n185 0 0 NMOD W=10u L=1u
Mp186 n186 n185 vdd vdd PMOD W=20u L=1u
CL186 n186 0 0.01p
Mn187 n187 n186 0 0 NMOD W=10u L=1u
Mp187 n187 n186 vdd vdd PMOD W=20u L=1u
CL187 n187 0 0.01p
Mn188 n188 n187 0 0 NMOD W=10u L=1u
Mp188 n188 n187 vdd vdd PMOD W=20u L=1u
CL188 n188 0 0.01p
Mn189 n189 n188 0 0 NMOD W=10u L=1u
Mp189 n189 n188 vdd vdd PMOD W=20u L=1u
CL189 n189 0 0.01p
Mn190 n190 n189 0 0 NMOD W=10u L=1u
Mp190 n190 n189 vdd vdd PMOD W=20u L=1u
CL190 n190 0 0.01p
Mn191 n191 n190 0 0 NMOD W=10u L=1u
Mp191 n191 n190 vdd vdd PMOD W=20u L=1u
CL191 n191 0 0.01p
Mn192 n192 n191 0 0 NMOD W=10u L=1u
Mp192 n192 n191 vdd vdd PMOD W=20u L=1u
CL192 n192 0 0.01p
Mn193 n193 n192 0 0 NMOD W=10u L=1u
Mp193 n193 n192 vdd vdd PMOD W=20u L=1u
CL193 n193 0 0.01p
Mn194 n194 n193 0 0 NMOD W=10u L=1u
Mp194 n194 n193 vdd vdd PMOD W=20u L=1u
CL194 n194 0 0.01p
Mn195 n195 n194 0 0 NMOD W=10u L=1u
Mp195 n195 n194 vdd vdd PMOD W=20u L=1u
CL195 n195 0 0.01p
Mn196 n196 n195 0 0 NMOD W=10u L=1u
Mp196 n196 n195 vdd vdd PMOD W=20u L=1u
CL196 n196 0 0.01p
Mn197 n197 n196 0 0 NMOD W=10u L=1u
Mp197 n197 n196 vdd vdd PMOD W=20u L=1u
CL197 n197 0 0.01p
Mn198 n198 n197 0 0 NMOD W=10u L=1u
Mp198 n198 n197 vdd vdd PMOD W=20u L=1u
CL198 n198 0 0.01p
Mn199 n199 n198 0 0 NMOD W=10u L=1u
Mp199 n199 n198 vdd vdd PMOD W=20u L=1u
CL199 n199 0 0.01p
Mn200 n200 n199 0 0 NMOD W=10u L=1u
Mp200 n200 n199 vdd vdd PMOD W=20u L=1u
CL200 n200 0 0.01p
Mn201 n201 n200 0 0 NMOD W=10u L=1u
Mp201 n201 n200 vdd vdd PMOD W=20u L=1u
CL201 n201 0 0.01p
Mn202 n202 n201 0 0 NMOD W=10u L=1u
Mp202 n202 n201 vdd vdd PMOD W=20u L=1u
CL202 n202 0 0.01p
Mn203 n203 n202 0 0 NMOD W=10u L=1u
Mp203 n203 n202 vdd vdd PMOD W=20u L=1u
CL203 n203 0 0.01p
Mn204 n204 n203 0 0 NMOD W=10u L=1u
Mp204 n204 n203 vdd vdd PMOD W=20u L=1u
CL204 n204 0 0.01p
Mn205 n205 n204 0 0 NMOD W=10u L=1u
Mp205 n205 n204 vdd vdd PMOD W=20u L=1u
CL205 n205 0 0.01p
Mn206 n206 n205 0 0 NMOD W=10u L=1u
Mp206 n206 n205 vdd vdd PMOD W=20u L=1u
CL206 n206 0 0.01p
Mn207 n207 n206 0 0 NMOD W=10u L=1u
Mp207 n207 n206 vdd vdd PMOD W=20u L=1u
CL207 n207 0 0.01p
Mn208 n208 n207 0 0 NMOD W=10u L=1u
Mp208 n208 n207 vdd vdd PMOD W=20u L=1u
CL208 n208 0 0.01p
Mn209 n209 n208 0 0 NMOD W=10u L=1u
Mp209 n209 n208 vdd vdd PMOD W=20u L=1u
CL209 n209 0 0.01p
Mn210 n210 n209 0 0 NMOD W=10u L=1u
Mp210 n210 n209 vdd vdd PMOD W=20u L=1u
CL210 n210 0 0.01p
Mn211 n211 n210 0 0 NMOD W=10u L=1u
Mp211 n211 n210 vdd vdd PMOD W=20u L=1u
CL211 n211 0 0.01p
Mn212 n212 n211 0 0 NMOD W=10u L=1u
Mp212 n212 n211 vdd vdd PMOD W=20u L=1u
CL212 n212 0 0.01p
Mn213 n213 n212 0 0 NMOD W=10u L=1u
Mp213 n213 n212 vdd vdd PMOD W=20u L=1u
CL213 n213 0 0.01p
Mn214 n214 n213 0 0 NMOD W=10u L=1u
Mp214 n214 n213 vdd vdd PMOD W=20u L=1u
CL214 n214 0 0.01p
Mn215 n215 n214 0 0 NMOD W=10u L=1u
Mp215 n215 n214 vdd vdd PMOD W=20u L=1u
CL215 n215 0 0.01p
Mn216 n216 n215 0 0 NMOD W=10u L=1u
Mp216 n216 n215 vdd vdd PMOD W=20u L=1u
CL216 n216 0 0.01p
Mn217 n217 n216 0 0 NMOD W=10u L=1u
Mp217 n217 n216 vdd vdd PMOD W=20u L=1u
CL217 n217 0 0.01p
Mn218 n218 n217 0 0 NMOD W=10u L=1u
Mp218 n218 n217 vdd vdd PMOD W=20u L=1u
CL218 n218 0 0.01p
Mn219 n219 n218 0 0 NMOD W=10u L=1u
Mp219 n219 n218 vdd vdd PMOD W=20u L=1u
CL219 n219 0 0.01p
Mn220 n220 n219 0 0 NMOD W=10u L=1u
Mp220 n220 n219 vdd vdd PMOD W=20u L=1u
CL220 n220 0 0.01p
Mn221 n221 n220 0 0 NMOD W=10u L=1u
Mp221 n221 n220 vdd vdd PMOD W=20u L=1u
CL221 n221 0 0.01p
Mn222 n222 n221 0 0 NMOD W=10u L=1u
Mp222 n222 n221 vdd vdd PMOD W=20u L=1u
CL222 n222 0 0.01p
Mn223 n223 n222 0 0 NMOD W=10u L=1u
Mp223 n223 n222 vdd vdd PMOD W=20u L=1u
CL223 n223 0 0.01p
Mn224 n224 n223 0 0 NMOD W=10u L=1u
Mp224 n224 n223 vdd vdd PMOD W=20u L=1u
CL224 n224 0 0.01p
Mn225 n225 n224 0 0 NMOD W=10u L=1u
Mp225 n225 n224 vdd vdd PMOD W=20u L=1u
CL225 n225 0 0.01p
Mn226 n226 n225 0 0 NMOD W=10u L=1u
Mp226 n226 n225 vdd vdd PMOD W=20u L=1u
CL226 n226 0 0.01p
Mn227 n227 n226 0 0 NMOD W=10u L=1u
Mp227 n227 n226 vdd vdd PMOD W=20u L=1u
CL227 n227 0 0.01p
Mn228 n228 n227 0 0 NMOD W=10u L=1u
Mp228 n228 n227 vdd vdd PMOD W=20u L=1u
CL228 n228 0 0.01p
Mn229 n229 n228 0 0 NMOD W=10u L=1u
Mp229 n229 n228 vdd vdd PMOD W=20u L=1u
CL229 n229 0 0.01p
Mn230 n230 n229 0 0 NMOD W=10u L=1u
Mp230 n230 n229 vdd vdd PMOD W=20u L=1u
CL230 n230 0 0.01p
Mn231 n231 n230 0 0 NMOD W=10u L=1u
Mp231 n231 n230 vdd vdd PMOD W=20u L=1u
CL231 n231 0 0.01p
Mn232 n232 n231 0 0 NMOD W=10u L=1u
Mp232 n232 n231 vdd vdd PMOD W=20u L=1u
CL232 n232 0 0.01p
Mn233 n233 n232 0 0 NMOD W=10u L=1u
Mp233 n233 n232 vdd vdd PMOD W=20u L=1u
CL233 n233 0 0.01p
Mn234 n234 n233 0 0 NMOD W=10u L=1u
Mp234 n234 n233 vdd vdd PMOD W=20u L=1u
CL234 n234 0 0.01p
Mn235 n235 n234 0 0 NMOD W=10u L=1u
Mp235 n235 n234 vdd vdd PMOD W=20u L=1u
CL235 n235 0 0.01p
Mn236 n236 n235 0 0 NMOD W=10u L=1u
Mp236 n236 n235 vdd vdd PMOD W=20u L=1u
CL236 n236 0 0.01p
Mn237 n237 n236 0 0 NMOD W=10u L=1u
Mp237 n237 n236 vdd vdd PMOD W=20u L=1u
CL237 n237 0 0.01p
Mn238 n238 n237 0 0 NMOD W=10u L=1u
Mp238 n238 n237 vdd vdd PMOD W=20u L=1u
CL238 n238 0 0.01p
Mn239 n239 n238 0 0 NMOD W=10u L=1u
Mp239 n239 n238 vdd vdd PMOD W=20u L=1u
CL239 n239 0 0.01p
Mn240 n240 n239 0 0 NMOD W=10u L=1u
Mp240 n240 n239 vdd vdd PMOD W=20u L=1u
CL240 n240 0 0.01p
Mn241 n241 n240 0 0 NMOD W=10u L=1u
Mp241 n241 n240 vdd vdd PMOD W=20u L=1u
CL241 n241 0 0.01p
Mn242 n242 n241 0 0 NMOD W=10u L=1u
Mp242 n242 n241 vdd vdd PMOD W=20u L=1u
CL242 n242 0 0.01p
Mn243 n243 n242 0 0 NMOD W=10u L=1u
Mp243 n243 n242 vdd vdd PMOD W=20u L=1u
CL243 n243 0 0.01p
Mn244 n244 n243 0 0 NMOD W=10u L=1u
Mp244 n244 n243 vdd vdd PMOD W=20u L=1u
CL244 n244 0 0.01p
Mn245 n245 n244 0 0 NMOD W=10u L=1u
Mp245 n245 n244 vdd vdd PMOD W=20u L=1u
CL245 n245 0 0.01p
Mn246 n246 n245 0 0 NMOD W=10u L=1u
Mp246 n246 n245 vdd vdd PMOD W=20u L=1u
CL246 n246 0 0.01p
Mn247 n247 n246 0 0 NMOD W=10u L=1u
Mp247 n247 n246 vdd vdd PMOD W=20u L=1u
CL247 n247 0 0.01p
Mn248 n248 n247 0 0 NMOD W=10u L=1u
Mp248 n248 n247 vdd vdd PMOD W=20u L=1u
CL248 n248 0 0.01p
Mn249 n249 n248 0 0 NMOD W=10u L=1u
Mp249 n249 n248 vdd vdd PMOD W=20u L=1u
CL249 n249 0 0.01p
Mn250 n250 n249 0 0 NMOD W=10u L=1u
Mp250 n250 n249 vdd vdd PMOD W=20u L=1u
CL250 n250 0 0.01p
Mn251 n251 n250 0 0 NMOD W=10u L=1u
Mp251 n251 n250 vdd vdd PMOD W=20u L=1u
CL251 n251 0 0.01p
Mn252 n252 n251 0 0 NMOD W=10u L=1u
Mp252 n252 n251 vdd vdd PMOD W=20u L=1u
CL252 n252 0 0.01p
Mn253 n253 n252 0 0 NMOD W=10u L=1u
Mp253 n253 n252 vdd vdd PMOD W=20u L=1u
CL253 n253 0 0.01p
Mn254 n254 n253 0 0 NMOD W=10u L=1u
Mp254 n254 n253 vdd vdd PMOD W=20u L=1u
CL254 n254 0 0.01p
Mn255 n255 n254 0 0 NMOD W=10u L=1u
Mp255 n255 n254 vdd vdd PMOD W=20u L=1u
CL255 n255 0 0.01p
Mn256 n256 n255 0 0 NMOD W=10u L=1u
Mp256 n256 n255 vdd vdd PMOD W=20u L=1u
CL256 n256 0 0.01p
Mn257 n257 n256 0 0 NMOD W=10u L=1u
Mp257 n257 n256 vdd vdd PMOD W=20u L=1u
CL257 n257 0 0.01p
Mn258 n258 n257 0 0 NMOD W=10u L=1u
Mp258 n258 n257 vdd vdd PMOD W=20u L=1u
CL258 n258 0 0.01p
Mn259 n259 n258 0 0 NMOD W=10u L=1u
Mp259 n259 n258 vdd vdd PMOD W=20u L=1u
CL259 n259 0 0.01p
Mn260 n260 n259 0 0 NMOD W=10u L=1u
Mp260 n260 n259 vdd vdd PMOD W=20u L=1u
CL260 n260 0 0.01p
Mn261 n261 n260 0 0 NMOD W=10u L=1u
Mp261 n261 n260 vdd vdd PMOD W=20u L=1u
CL261 n261 0 0.01p
Mn262 n262 n261 0 0 NMOD W=10u L=1u
Mp262 n262 n261 vdd vdd PMOD W=20u L=1u
CL262 n262 0 0.01p
Mn263 n263 n262 0 0 NMOD W=10u L=1u
Mp263 n263 n262 vdd vdd PMOD W=20u L=1u
CL263 n263 0 0.01p
Mn264 n264 n263 0 0 NMOD W=10u L=1u
Mp264 n264 n263 vdd vdd PMOD W=20u L=1u
CL264 n264 0 0.01p
Mn265 n265 n264 0 0 NMOD W=10u L=1u
Mp265 n265 n264 vdd vdd PMOD W=20u L=1u
CL265 n265 0 0.01p
Mn266 n266 n265 0 0 NMOD W=10u L=1u
Mp266 n266 n265 vdd vdd PMOD W=20u L=1u
CL266 n266 0 0.01p
Mn267 n267 n266 0 0 NMOD W=10u L=1u
Mp267 n267 n266 vdd vdd PMOD W=20u L=1u
CL267 n267 0 0.01p
Mn268 n268 n267 0 0 NMOD W=10u L=1u
Mp268 n268 n267 vdd vdd PMOD W=20u L=1u
CL268 n268 0 0.01p
Mn269 n269 n268 0 0 NMOD W=10u L=1u
Mp269 n269 n268 vdd vdd PMOD W=20u L=1u
CL269 n269 0 0.01p
Mn270 n270 n269 0 0 NMOD W=10u L=1u
Mp270 n270 n269 vdd vdd PMOD W=20u L=1u
CL270 n270 0 0.01p
Mn271 n271 n270 0 0 NMOD W=10u L=1u
Mp271 n271 n270 vdd vdd PMOD W=20u L=1u
CL271 n271 0 0.01p
Mn272 n272 n271 0 0 NMOD W=10u L=1u
Mp272 n272 n271 vdd vdd PMOD W=20u L=1u
CL272 n272 0 0.01p
Mn273 n273 n272 0 0 NMOD W=10u L=1u
Mp273 n273 n272 vdd vdd PMOD W=20u L=1u
CL273 n273 0 0.01p
Mn274 n274 n273 0 0 NMOD W=10u L=1u
Mp274 n274 n273 vdd vdd PMOD W=20u L=1u
CL274 n274 0 0.01p
Mn275 n275 n274 0 0 NMOD W=10u L=1u
Mp275 n275 n274 vdd vdd PMOD W=20u L=1u
CL275 n275 0 0.01p
Mn276 n276 n275 0 0 NMOD W=10u L=1u
Mp276 n276 n275 vdd vdd PMOD W=20u L=1u
CL276 n276 0 0.01p
Mn277 n277 n276 0 0 NMOD W=10u L=1u
Mp277 n277 n276 vdd vdd PMOD W=20u L=1u
CL277 n277 0 0.01p
Mn278 n278 n277 0 0 NMOD W=10u L=1u
Mp278 n278 n277 vdd vdd PMOD W=20u L=1u
CL278 n278 0 0.01p
Mn279 n279 n278 0 0 NMOD W=10u L=1u
Mp279 n279 n278 vdd vdd PMOD W=20u L=1u
CL279 n279 0 0.01p
Mn280 n280 n279 0 0 NMOD W=10u L=1u
Mp280 n280 n279 vdd vdd PMOD W=20u L=1u
CL280 n280 0 0.01p
Mn281 n281 n280 0 0 NMOD W=10u L=1u
Mp281 n281 n280 vdd vdd PMOD W=20u L=1u
CL281 n281 0 0.01p
Mn282 n282 n281 0 0 NMOD W=10u L=1u
Mp282 n282 n281 vdd vdd PMOD W=20u L=1u
CL282 n282 0 0.01p
Mn283 n283 n282 0 0 NMOD W=10u L=1u
Mp283 n283 n282 vdd vdd PMOD W=20u L=1u
CL283 n283 0 0.01p
Mn284 n284 n283 0 0 NMOD W=10u L=1u
Mp284 n284 n283 vdd vdd PMOD W=20u L=1u
CL284 n284 0 0.01p
Mn285 n285 n284 0 0 NMOD W=10u L=1u
Mp285 n285 n284 vdd vdd PMOD W=20u L=1u
CL285 n285 0 0.01p
Mn286 n286 n285 0 0 NMOD W=10u L=1u
Mp286 n286 n285 vdd vdd PMOD W=20u L=1u
CL286 n286 0 0.01p
Mn287 n287 n286 0 0 NMOD W=10u L=1u
Mp287 n287 n286 vdd vdd PMOD W=20u L=1u
CL287 n287 0 0.01p
Mn288 n288 n287 0 0 NMOD W=10u L=1u
Mp288 n288 n287 vdd vdd PMOD W=20u L=1u
CL288 n288 0 0.01p
Mn289 n289 n288 0 0 NMOD W=10u L=1u
Mp289 n289 n288 vdd vdd PMOD W=20u L=1u
CL289 n289 0 0.01p
Mn290 n290 n289 0 0 NMOD W=10u L=1u
Mp290 n290 n289 vdd vdd PMOD W=20u L=1u
CL290 n290 0 0.01p
Mn291 n291 n290 0 0 NMOD W=10u L=1u
Mp291 n291 n290 vdd vdd PMOD W=20u L=1u
CL291 n291 0 0.01p
Mn292 n292 n291 0 0 NMOD W=10u L=1u
Mp292 n292 n291 vdd vdd PMOD W=20u L=1u
CL292 n292 0 0.01p
Mn293 n293 n292 0 0 NMOD W=10u L=1u
Mp293 n293 n292 vdd vdd PMOD W=20u L=1u
CL293 n293 0 0.01p
Mn294 n294 n293 0 0 NMOD W=10u L=1u
Mp294 n294 n293 vdd vdd PMOD W=20u L=1u
CL294 n294 0 0.01p
Mn295 n295 n294 0 0 NMOD W=10u L=1u
Mp295 n295 n294 vdd vdd PMOD W=20u L=1u
CL295 n295 0 0.01p
Mn296 n296 n295 0 0 NMOD W=10u L=1u
Mp296 n296 n295 vdd vdd PMOD W=20u L=1u
CL296 n296 0 0.01p
Mn297 n297 n296 0 0 NMOD W=10u L=1u
Mp297 n297 n296 vdd vdd PMOD W=20u L=1u
CL297 n297 0 0.01p
Mn298 n298 n297 0 0 NMOD W=10u L=1u
Mp298 n298 n297 vdd vdd PMOD W=20u L=1u
CL298 n298 0 0.01p
Mn299 n299 n298 0 0 NMOD W=10u L=1u
Mp299 n299 n298 vdd vdd PMOD W=20u L=1u
CL299 n299 0 0.01p
Mn300 n300 n299 0 0 NMOD W=10u L=1u
Mp300 n300 n299 vdd vdd PMOD W=20u L=1u
CL300 n300 0 0.01p
Mn301 n301 n300 0 0 NMOD W=10u L=1u
Mp301 n301 n300 vdd vdd PMOD W=20u L=1u
CL301 n301 0 0.01p
Mn302 n302 n301 0 0 NMOD W=10u L=1u
Mp302 n302 n301 vdd vdd PMOD W=20u L=1u
CL302 n302 0 0.01p
Mn303 n303 n302 0 0 NMOD W=10u L=1u
Mp303 n303 n302 vdd vdd PMOD W=20u L=1u
CL303 n303 0 0.01p
Mn304 n304 n303 0 0 NMOD W=10u L=1u
Mp304 n304 n303 vdd vdd PMOD W=20u L=1u
CL304 n304 0 0.01p
Mn305 n305 n304 0 0 NMOD W=10u L=1u
Mp305 n305 n304 vdd vdd PMOD W=20u L=1u
CL305 n305 0 0.01p
Mn306 n306 n305 0 0 NMOD W=10u L=1u
Mp306 n306 n305 vdd vdd PMOD W=20u L=1u
CL306 n306 0 0.01p
Mn307 n307 n306 0 0 NMOD W=10u L=1u
Mp307 n307 n306 vdd vdd PMOD W=20u L=1u
CL307 n307 0 0.01p
Mn308 n308 n307 0 0 NMOD W=10u L=1u
Mp308 n308 n307 vdd vdd PMOD W=20u L=1u
CL308 n308 0 0.01p
Mn309 n309 n308 0 0 NMOD W=10u L=1u
Mp309 n309 n308 vdd vdd PMOD W=20u L=1u
CL309 n309 0 0.01p
Mn310 n310 n309 0 0 NMOD W=10u L=1u
Mp310 n310 n309 vdd vdd PMOD W=20u L=1u
CL310 n310 0 0.01p
Mn311 n311 n310 0 0 NMOD W=10u L=1u
Mp311 n311 n310 vdd vdd PMOD W=20u L=1u
CL311 n311 0 0.01p
Mn312 n312 n311 0 0 NMOD W=10u L=1u
Mp312 n312 n311 vdd vdd PMOD W=20u L=1u
CL312 n312 0 0.01p
Mn313 n313 n312 0 0 NMOD W=10u L=1u
Mp313 n313 n312 vdd vdd PMOD W=20u L=1u
CL313 n313 0 0.01p
Mn314 n314 n313 0 0 NMOD W=10u L=1u
Mp314 n314 n313 vdd vdd PMOD W=20u L=1u
CL314 n314 0 0.01p
Mn315 n315 n314 0 0 NMOD W=10u L=1u
Mp315 n315 n314 vdd vdd PMOD W=20u L=1u
CL315 n315 0 0.01p
Mn316 n316 n315 0 0 NMOD W=10u L=1u
Mp316 n316 n315 vdd vdd PMOD W=20u L=1u
CL316 n316 0 0.01p
Mn317 n317 n316 0 0 NMOD W=10u L=1u
Mp317 n317 n316 vdd vdd PMOD W=20u L=1u
CL317 n317 0 0.01p
Mn318 n318 n317 0 0 NMOD W=10u L=1u
Mp318 n318 n317 vdd vdd PMOD W=20u L=1u
CL318 n318 0 0.01p
Mn319 n319 n318 0 0 NMOD W=10u L=1u
Mp319 n319 n318 vdd vdd PMOD W=20u L=1u
CL319 n319 0 0.01p
Mn320 n320 n319 0 0 NMOD W=10u L=1u
Mp320 n320 n319 vdd vdd PMOD W=20u L=1u
CL320 n320 0 0.01p
Mn321 n321 n320 0 0 NMOD W=10u L=1u
Mp321 n321 n320 vdd vdd PMOD W=20u L=1u
CL321 n321 0 0.01p
Mn322 n322 n321 0 0 NMOD W=10u L=1u
Mp322 n322 n321 vdd vdd PMOD W=20u L=1u
CL322 n322 0 0.01p
Mn323 n323 n322 0 0 NMOD W=10u L=1u
Mp323 n323 n322 vdd vdd PMOD W=20u L=1u
CL323 n323 0 0.01p
Mn324 n324 n323 0 0 NMOD W=10u L=1u
Mp324 n324 n323 vdd vdd PMOD W=20u L=1u
CL324 n324 0 0.01p
Mn325 n325 n324 0 0 NMOD W=10u L=1u
Mp325 n325 n324 vdd vdd PMOD W=20u L=1u
CL325 n325 0 0.01p
Mn326 n326 n325 0 0 NMOD W=10u L=1u
Mp326 n326 n325 vdd vdd PMOD W=20u L=1u
CL326 n326 0 0.01p
Mn327 n327 n326 0 0 NMOD W=10u L=1u
Mp327 n327 n326 vdd vdd PMOD W=20u L=1u
CL327 n327 0 0.01p
Mn328 n328 n327 0 0 NMOD W=10u L=1u
Mp328 n328 n327 vdd vdd PMOD W=20u L=1u
CL328 n328 0 0.01p
Mn329 n329 n328 0 0 NMOD W=10u L=1u
Mp329 n329 n328 vdd vdd PMOD W=20u L=1u
CL329 n329 0 0.01p
Mn330 n330 n329 0 0 NMOD W=10u L=1u
Mp330 n330 n329 vdd vdd PMOD W=20u L=1u
CL330 n330 0 0.01p
Mn331 n331 n330 0 0 NMOD W=10u L=1u
Mp331 n331 n330 vdd vdd PMOD W=20u L=1u
CL331 n331 0 0.01p
Mn332 n332 n331 0 0 NMOD W=10u L=1u
Mp332 n332 n331 vdd vdd PMOD W=20u L=1u
CL332 n332 0 0.01p
Mn333 n333 n332 0 0 NMOD W=10u L=1u
Mp333 n333 n332 vdd vdd PMOD W=20u L=1u
CL333 n333 0 0.01p
Mn334 n334 n333 0 0 NMOD W=10u L=1u
Mp334 n334 n333 vdd vdd PMOD W=20u L=1u
CL334 n334 0 0.01p
Mn335 n335 n334 0 0 NMOD W=10u L=1u
Mp335 n335 n334 vdd vdd PMOD W=20u L=1u
CL335 n335 0 0.01p
Mn336 n336 n335 0 0 NMOD W=10u L=1u
Mp336 n336 n335 vdd vdd PMOD W=20u L=1u
CL336 n336 0 0.01p
Mn337 n337 n336 0 0 NMOD W=10u L=1u
Mp337 n337 n336 vdd vdd PMOD W=20u L=1u
CL337 n337 0 0.01p
Mn338 n338 n337 0 0 NMOD W=10u L=1u
Mp338 n338 n337 vdd vdd PMOD W=20u L=1u
CL338 n338 0 0.01p
Mn339 n339 n338 0 0 NMOD W=10u L=1u
Mp339 n339 n338 vdd vdd PMOD W=20u L=1u
CL339 n339 0 0.01p
Mn340 n340 n339 0 0 NMOD W=10u L=1u
Mp340 n340 n339 vdd vdd PMOD W=20u L=1u
CL340 n340 0 0.01p
Mn341 n341 n340 0 0 NMOD W=10u L=1u
Mp341 n341 n340 vdd vdd PMOD W=20u L=1u
CL341 n341 0 0.01p
Mn342 n342 n341 0 0 NMOD W=10u L=1u
Mp342 n342 n341 vdd vdd PMOD W=20u L=1u
CL342 n342 0 0.01p
Mn343 n343 n342 0 0 NMOD W=10u L=1u
Mp343 n343 n342 vdd vdd PMOD W=20u L=1u
CL343 n343 0 0.01p
Mn344 n344 n343 0 0 NMOD W=10u L=1u
Mp344 n344 n343 vdd vdd PMOD W=20u L=1u
CL344 n344 0 0.01p
Mn345 n345 n344 0 0 NMOD W=10u L=1u
Mp345 n345 n344 vdd vdd PMOD W=20u L=1u
CL345 n345 0 0.01p
Mn346 n346 n345 0 0 NMOD W=10u L=1u
Mp346 n346 n345 vdd vdd PMOD W=20u L=1u
CL346 n346 0 0.01p
Mn347 n347 n346 0 0 NMOD W=10u L=1u
Mp347 n347 n346 vdd vdd PMOD W=20u L=1u
CL347 n347 0 0.01p
Mn348 n348 n347 0 0 NMOD W=10u L=1u
Mp348 n348 n347 vdd vdd PMOD W=20u L=1u
CL348 n348 0 0.01p
Mn349 n349 n348 0 0 NMOD W=10u L=1u
Mp349 n349 n348 vdd vdd PMOD W=20u L=1u
CL349 n349 0 0.01p
Mn350 n350 n349 0 0 NMOD W=10u L=1u
Mp350 n350 n349 vdd vdd PMOD W=20u L=1u
CL350 n350 0 0.01p
Mn351 n351 n350 0 0 NMOD W=10u L=1u
Mp351 n351 n350 vdd vdd PMOD W=20u L=1u
CL351 n351 0 0.01p
Mn352 n352 n351 0 0 NMOD W=10u L=1u
Mp352 n352 n351 vdd vdd PMOD W=20u L=1u
CL352 n352 0 0.01p
Mn353 n353 n352 0 0 NMOD W=10u L=1u
Mp353 n353 n352 vdd vdd PMOD W=20u L=1u
CL353 n353 0 0.01p
Mn354 n354 n353 0 0 NMOD W=10u L=1u
Mp354 n354 n353 vdd vdd PMOD W=20u L=1u
CL354 n354 0 0.01p
Mn355 n355 n354 0 0 NMOD W=10u L=1u
Mp355 n355 n354 vdd vdd PMOD W=20u L=1u
CL355 n355 0 0.01p
Mn356 n356 n355 0 0 NMOD W=10u L=1u
Mp356 n356 n355 vdd vdd PMOD W=20u L=1u
CL356 n356 0 0.01p
Mn357 n357 n356 0 0 NMOD W=10u L=1u
Mp357 n357 n356 vdd vdd PMOD W=20u L=1u
CL357 n357 0 0.01p
Mn358 n358 n357 0 0 NMOD W=10u L=1u
Mp358 n358 n357 vdd vdd PMOD W=20u L=1u
CL358 n358 0 0.01p
Mn359 n359 n358 0 0 NMOD W=10u L=1u
Mp359 n359 n358 vdd vdd PMOD W=20u L=1u
CL359 n359 0 0.01p
Mn360 n360 n359 0 0 NMOD W=10u L=1u
Mp360 n360 n359 vdd vdd PMOD W=20u L=1u
CL360 n360 0 0.01p
Mn361 n361 n360 0 0 NMOD W=10u L=1u
Mp361 n361 n360 vdd vdd PMOD W=20u L=1u
CL361 n361 0 0.01p
Mn362 n362 n361 0 0 NMOD W=10u L=1u
Mp362 n362 n361 vdd vdd PMOD W=20u L=1u
CL362 n362 0 0.01p
Mn363 n363 n362 0 0 NMOD W=10u L=1u
Mp363 n363 n362 vdd vdd PMOD W=20u L=1u
CL363 n363 0 0.01p
Mn364 n364 n363 0 0 NMOD W=10u L=1u
Mp364 n364 n363 vdd vdd PMOD W=20u L=1u
CL364 n364 0 0.01p
Mn365 n365 n364 0 0 NMOD W=10u L=1u
Mp365 n365 n364 vdd vdd PMOD W=20u L=1u
CL365 n365 0 0.01p
Mn366 n366 n365 0 0 NMOD W=10u L=1u
Mp366 n366 n365 vdd vdd PMOD W=20u L=1u
CL366 n366 0 0.01p
Mn367 n367 n366 0 0 NMOD W=10u L=1u
Mp367 n367 n366 vdd vdd PMOD W=20u L=1u
CL367 n367 0 0.01p
Mn368 n368 n367 0 0 NMOD W=10u L=1u
Mp368 n368 n367 vdd vdd PMOD W=20u L=1u
CL368 n368 0 0.01p
Mn369 n369 n368 0 0 NMOD W=10u L=1u
Mp369 n369 n368 vdd vdd PMOD W=20u L=1u
CL369 n369 0 0.01p
Mn370 n370 n369 0 0 NMOD W=10u L=1u
Mp370 n370 n369 vdd vdd PMOD W=20u L=1u
CL370 n370 0 0.01p
Mn371 n371 n370 0 0 NMOD W=10u L=1u
Mp371 n371 n370 vdd vdd PMOD W=20u L=1u
CL371 n371 0 0.01p
Mn372 n372 n371 0 0 NMOD W=10u L=1u
Mp372 n372 n371 vdd vdd PMOD W=20u L=1u
CL372 n372 0 0.01p
Mn373 n373 n372 0 0 NMOD W=10u L=1u
Mp373 n373 n372 vdd vdd PMOD W=20u L=1u
CL373 n373 0 0.01p
Mn374 n374 n373 0 0 NMOD W=10u L=1u
Mp374 n374 n373 vdd vdd PMOD W=20u L=1u
CL374 n374 0 0.01p
Mn375 n375 n374 0 0 NMOD W=10u L=1u
Mp375 n375 n374 vdd vdd PMOD W=20u L=1u
CL375 n375 0 0.01p
Mn376 n376 n375 0 0 NMOD W=10u L=1u
Mp376 n376 n375 vdd vdd PMOD W=20u L=1u
CL376 n376 0 0.01p
Mn377 n377 n376 0 0 NMOD W=10u L=1u
Mp377 n377 n376 vdd vdd PMOD W=20u L=1u
CL377 n377 0 0.01p
Mn378 n378 n377 0 0 NMOD W=10u L=1u
Mp378 n378 n377 vdd vdd PMOD W=20u L=1u
CL378 n378 0 0.01p
Mn379 n379 n378 0 0 NMOD W=10u L=1u
Mp379 n379 n378 vdd vdd PMOD W=20u L=1u
CL379 n379 0 0.01p
Mn380 n380 n379 0 0 NMOD W=10u L=1u
Mp380 n380 n379 vdd vdd PMOD W=20u L=1u
CL380 n380 0 0.01p
Mn381 n381 n380 0 0 NMOD W=10u L=1u
Mp381 n381 n380 vdd vdd PMOD W=20u L=1u
CL381 n381 0 0.01p
Mn382 n382 n381 0 0 NMOD W=10u L=1u
Mp382 n382 n381 vdd vdd PMOD W=20u L=1u
CL382 n382 0 0.01p
Mn383 n383 n382 0 0 NMOD W=10u L=1u
Mp383 n383 n382 vdd vdd PMOD W=20u L=1u
CL383 n383 0 0.01p
Mn384 n384 n383 0 0 NMOD W=10u L=1u
Mp384 n384 n383 vdd vdd PMOD W=20u L=1u
CL384 n384 0 0.01p
Mn385 n385 n384 0 0 NMOD W=10u L=1u
Mp385 n385 n384 vdd vdd PMOD W=20u L=1u
CL385 n385 0 0.01p
Mn386 n386 n385 0 0 NMOD W=10u L=1u
Mp386 n386 n385 vdd vdd PMOD W=20u L=1u
CL386 n386 0 0.01p
Mn387 n387 n386 0 0 NMOD W=10u L=1u
Mp387 n387 n386 vdd vdd PMOD W=20u L=1u
CL387 n387 0 0.01p
Mn388 n388 n387 0 0 NMOD W=10u L=1u
Mp388 n388 n387 vdd vdd PMOD W=20u L=1u
CL388 n388 0 0.01p
Mn389 n389 n388 0 0 NMOD W=10u L=1u
Mp389 n389 n388 vdd vdd PMOD W=20u L=1u
CL389 n389 0 0.01p
Mn390 n390 n389 0 0 NMOD W=10u L=1u
Mp390 n390 n389 vdd vdd PMOD W=20u L=1u
CL390 n390 0 0.01p
Mn391 n391 n390 0 0 NMOD W=10u L=1u
Mp391 n391 n390 vdd vdd PMOD W=20u L=1u
CL391 n391 0 0.01p
Mn392 n392 n391 0 0 NMOD W=10u L=1u
Mp392 n392 n391 vdd vdd PMOD W=20u L=1u
CL392 n392 0 0.01p
Mn393 n393 n392 0 0 NMOD W=10u L=1u
Mp393 n393 n392 vdd vdd PMOD W=20u L=1u
CL393 n393 0 0.01p
Mn394 n394 n393 0 0 NMOD W=10u L=1u
Mp394 n394 n393 vdd vdd PMOD W=20u L=1u
CL394 n394 0 0.01p
Mn395 n395 n394 0 0 NMOD W=10u L=1u
Mp395 n395 n394 vdd vdd PMOD W=20u L=1u
CL395 n395 0 0.01p
Mn396 n396 n395 0 0 NMOD W=10u L=1u
Mp396 n396 n395 vdd vdd PMOD W=20u L=1u
CL396 n396 0 0.01p
Mn397 n397 n396 0 0 NMOD W=10u L=1u
Mp397 n397 n396 vdd vdd PMOD W=20u L=1u
CL397 n397 0 0.01p
Mn398 n398 n397 0 0 NMOD W=10u L=1u
Mp398 n398 n397 vdd vdd PMOD W=20u L=1u
CL398 n398 0 0.01p
Mn399 n399 n398 0 0 NMOD W=10u L=1u
Mp399 n399 n398 vdd vdd PMOD W=20u L=1u
CL399 n399 0 0.01p
Mn400 n400 n399 0 0 NMOD W=10u L=1u
Mp400 n400 n399 vdd vdd PMOD W=20u L=1u
CL400 n400 0 0.01p
Mn401 n401 n400 0 0 NMOD W=10u L=1u
Mp401 n401 n400 vdd vdd PMOD W=20u L=1u
CL401 n401 0 0.01p
Mn402 n402 n401 0 0 NMOD W=10u L=1u
Mp402 n402 n401 vdd vdd PMOD W=20u L=1u
CL402 n402 0 0.01p
Mn403 n403 n402 0 0 NMOD W=10u L=1u
Mp403 n403 n402 vdd vdd PMOD W=20u L=1u
CL403 n403 0 0.01p
Mn404 n404 n403 0 0 NMOD W=10u L=1u
Mp404 n404 n403 vdd vdd PMOD W=20u L=1u
CL404 n404 0 0.01p
Mn405 n405 n404 0 0 NMOD W=10u L=1u
Mp405 n405 n404 vdd vdd PMOD W=20u L=1u
CL405 n405 0 0.01p
Mn406 n406 n405 0 0 NMOD W=10u L=1u
Mp406 n406 n405 vdd vdd PMOD W=20u L=1u
CL406 n406 0 0.01p
Mn407 n407 n406 0 0 NMOD W=10u L=1u
Mp407 n407 n406 vdd vdd PMOD W=20u L=1u
CL407 n407 0 0.01p
Mn408 n408 n407 0 0 NMOD W=10u L=1u
Mp408 n408 n407 vdd vdd PMOD W=20u L=1u
CL408 n408 0 0.01p
Mn409 n409 n408 0 0 NMOD W=10u L=1u
Mp409 n409 n408 vdd vdd PMOD W=20u L=1u
CL409 n409 0 0.01p
Mn410 n410 n409 0 0 NMOD W=10u L=1u
Mp410 n410 n409 vdd vdd PMOD W=20u L=1u
CL410 n410 0 0.01p
Mn411 n411 n410 0 0 NMOD W=10u L=1u
Mp411 n411 n410 vdd vdd PMOD W=20u L=1u
CL411 n411 0 0.01p
Mn412 n412 n411 0 0 NMOD W=10u L=1u
Mp412 n412 n411 vdd vdd PMOD W=20u L=1u
CL412 n412 0 0.01p
Mn413 n413 n412 0 0 NMOD W=10u L=1u
Mp413 n413 n412 vdd vdd PMOD W=20u L=1u
CL413 n413 0 0.01p
Mn414 n414 n413 0 0 NMOD W=10u L=1u
Mp414 n414 n413 vdd vdd PMOD W=20u L=1u
CL414 n414 0 0.01p
Mn415 n415 n414 0 0 NMOD W=10u L=1u
Mp415 n415 n414 vdd vdd PMOD W=20u L=1u
CL415 n415 0 0.01p
Mn416 n416 n415 0 0 NMOD W=10u L=1u
Mp416 n416 n415 vdd vdd PMOD W=20u L=1u
CL416 n416 0 0.01p
Mn417 n417 n416 0 0 NMOD W=10u L=1u
Mp417 n417 n416 vdd vdd PMOD W=20u L=1u
CL417 n417 0 0.01p
Mn418 n418 n417 0 0 NMOD W=10u L=1u
Mp418 n418 n417 vdd vdd PMOD W=20u L=1u
CL418 n418 0 0.01p
Mn419 n419 n418 0 0 NMOD W=10u L=1u
Mp419 n419 n418 vdd vdd PMOD W=20u L=1u
CL419 n419 0 0.01p
Mn420 n420 n419 0 0 NMOD W=10u L=1u
Mp420 n420 n419 vdd vdd PMOD W=20u L=1u
CL420 n420 0 0.01p
Mn421 n421 n420 0 0 NMOD W=10u L=1u
Mp421 n421 n420 vdd vdd PMOD W=20u L=1u
CL421 n421 0 0.01p
Mn422 n422 n421 0 0 NMOD W=10u L=1u
Mp422 n422 n421 vdd vdd PMOD W=20u L=1u
CL422 n422 0 0.01p
Mn423 n423 n422 0 0 NMOD W=10u L=1u
Mp423 n423 n422 vdd vdd PMOD W=20u L=1u
CL423 n423 0 0.01p
Mn424 n424 n423 0 0 NMOD W=10u L=1u
Mp424 n424 n423 vdd vdd PMOD W=20u L=1u
CL424 n424 0 0.01p
Mn425 n425 n424 0 0 NMOD W=10u L=1u
Mp425 n425 n424 vdd vdd PMOD W=20u L=1u
CL425 n425 0 0.01p
Mn426 n426 n425 0 0 NMOD W=10u L=1u
Mp426 n426 n425 vdd vdd PMOD W=20u L=1u
CL426 n426 0 0.01p
Mn427 n427 n426 0 0 NMOD W=10u L=1u
Mp427 n427 n426 vdd vdd PMOD W=20u L=1u
CL427 n427 0 0.01p
Mn428 n428 n427 0 0 NMOD W=10u L=1u
Mp428 n428 n427 vdd vdd PMOD W=20u L=1u
CL428 n428 0 0.01p
Mn429 n429 n428 0 0 NMOD W=10u L=1u
Mp429 n429 n428 vdd vdd PMOD W=20u L=1u
CL429 n429 0 0.01p
Mn430 n430 n429 0 0 NMOD W=10u L=1u
Mp430 n430 n429 vdd vdd PMOD W=20u L=1u
CL430 n430 0 0.01p
Mn431 n431 n430 0 0 NMOD W=10u L=1u
Mp431 n431 n430 vdd vdd PMOD W=20u L=1u
CL431 n431 0 0.01p
Mn432 n432 n431 0 0 NMOD W=10u L=1u
Mp432 n432 n431 vdd vdd PMOD W=20u L=1u
CL432 n432 0 0.01p
Mn433 n433 n432 0 0 NMOD W=10u L=1u
Mp433 n433 n432 vdd vdd PMOD W=20u L=1u
CL433 n433 0 0.01p
Mn434 n434 n433 0 0 NMOD W=10u L=1u
Mp434 n434 n433 vdd vdd PMOD W=20u L=1u
CL434 n434 0 0.01p
Mn435 n435 n434 0 0 NMOD W=10u L=1u
Mp435 n435 n434 vdd vdd PMOD W=20u L=1u
CL435 n435 0 0.01p
Mn436 n436 n435 0 0 NMOD W=10u L=1u
Mp436 n436 n435 vdd vdd PMOD W=20u L=1u
CL436 n436 0 0.01p
Mn437 n437 n436 0 0 NMOD W=10u L=1u
Mp437 n437 n436 vdd vdd PMOD W=20u L=1u
CL437 n437 0 0.01p
Mn438 n438 n437 0 0 NMOD W=10u L=1u
Mp438 n438 n437 vdd vdd PMOD W=20u L=1u
CL438 n438 0 0.01p
Mn439 n439 n438 0 0 NMOD W=10u L=1u
Mp439 n439 n438 vdd vdd PMOD W=20u L=1u
CL439 n439 0 0.01p
Mn440 n440 n439 0 0 NMOD W=10u L=1u
Mp440 n440 n439 vdd vdd PMOD W=20u L=1u
CL440 n440 0 0.01p
Mn441 n441 n440 0 0 NMOD W=10u L=1u
Mp441 n441 n440 vdd vdd PMOD W=20u L=1u
CL441 n441 0 0.01p
Mn442 n442 n441 0 0 NMOD W=10u L=1u
Mp442 n442 n441 vdd vdd PMOD W=20u L=1u
CL442 n442 0 0.01p
Mn443 n443 n442 0 0 NMOD W=10u L=1u
Mp443 n443 n442 vdd vdd PMOD W=20u L=1u
CL443 n443 0 0.01p
Mn444 n444 n443 0 0 NMOD W=10u L=1u
Mp444 n444 n443 vdd vdd PMOD W=20u L=1u
CL444 n444 0 0.01p
Mn445 n445 n444 0 0 NMOD W=10u L=1u
Mp445 n445 n444 vdd vdd PMOD W=20u L=1u
CL445 n445 0 0.01p
Mn446 n446 n445 0 0 NMOD W=10u L=1u
Mp446 n446 n445 vdd vdd PMOD W=20u L=1u
CL446 n446 0 0.01p
Mn447 n447 n446 0 0 NMOD W=10u L=1u
Mp447 n447 n446 vdd vdd PMOD W=20u L=1u
CL447 n447 0 0.01p
Mn448 n448 n447 0 0 NMOD W=10u L=1u
Mp448 n448 n447 vdd vdd PMOD W=20u L=1u
CL448 n448 0 0.01p
Mn449 n449 n448 0 0 NMOD W=10u L=1u
Mp449 n449 n448 vdd vdd PMOD W=20u L=1u
CL449 n449 0 0.01p
Mn450 n450 n449 0 0 NMOD W=10u L=1u
Mp450 n450 n449 vdd vdd PMOD W=20u L=1u
CL450 n450 0 0.01p
Mn451 n451 n450 0 0 NMOD W=10u L=1u
Mp451 n451 n450 vdd vdd PMOD W=20u L=1u
CL451 n451 0 0.01p
Mn452 n452 n451 0 0 NMOD W=10u L=1u
Mp452 n452 n451 vdd vdd PMOD W=20u L=1u
CL452 n452 0 0.01p
Mn453 n453 n452 0 0 NMOD W=10u L=1u
Mp453 n453 n452 vdd vdd PMOD W=20u L=1u
CL453 n453 0 0.01p
Mn454 n454 n453 0 0 NMOD W=10u L=1u
Mp454 n454 n453 vdd vdd PMOD W=20u L=1u
CL454 n454 0 0.01p
Mn455 n455 n454 0 0 NMOD W=10u L=1u
Mp455 n455 n454 vdd vdd PMOD W=20u L=1u
CL455 n455 0 0.01p
Mn456 n456 n455 0 0 NMOD W=10u L=1u
Mp456 n456 n455 vdd vdd PMOD W=20u L=1u
CL456 n456 0 0.01p
Mn457 n457 n456 0 0 NMOD W=10u L=1u
Mp457 n457 n456 vdd vdd PMOD W=20u L=1u
CL457 n457 0 0.01p
Mn458 n458 n457 0 0 NMOD W=10u L=1u
Mp458 n458 n457 vdd vdd PMOD W=20u L=1u
CL458 n458 0 0.01p
Mn459 n459 n458 0 0 NMOD W=10u L=1u
Mp459 n459 n458 vdd vdd PMOD W=20u L=1u
CL459 n459 0 0.01p
Mn460 n460 n459 0 0 NMOD W=10u L=1u
Mp460 n460 n459 vdd vdd PMOD W=20u L=1u
CL460 n460 0 0.01p
Mn461 n461 n460 0 0 NMOD W=10u L=1u
Mp461 n461 n460 vdd vdd PMOD W=20u L=1u
CL461 n461 0 0.01p
Mn462 n462 n461 0 0 NMOD W=10u L=1u
Mp462 n462 n461 vdd vdd PMOD W=20u L=1u
CL462 n462 0 0.01p
Mn463 n463 n462 0 0 NMOD W=10u L=1u
Mp463 n463 n462 vdd vdd PMOD W=20u L=1u
CL463 n463 0 0.01p
Mn464 n464 n463 0 0 NMOD W=10u L=1u
Mp464 n464 n463 vdd vdd PMOD W=20u L=1u
CL464 n464 0 0.01p
Mn465 n465 n464 0 0 NMOD W=10u L=1u
Mp465 n465 n464 vdd vdd PMOD W=20u L=1u
CL465 n465 0 0.01p
Mn466 n466 n465 0 0 NMOD W=10u L=1u
Mp466 n466 n465 vdd vdd PMOD W=20u L=1u
CL466 n466 0 0.01p
Mn467 n467 n466 0 0 NMOD W=10u L=1u
Mp467 n467 n466 vdd vdd PMOD W=20u L=1u
CL467 n467 0 0.01p
Mn468 n468 n467 0 0 NMOD W=10u L=1u
Mp468 n468 n467 vdd vdd PMOD W=20u L=1u
CL468 n468 0 0.01p
Mn469 n469 n468 0 0 NMOD W=10u L=1u
Mp469 n469 n468 vdd vdd PMOD W=20u L=1u
CL469 n469 0 0.01p
Mn470 n470 n469 0 0 NMOD W=10u L=1u
Mp470 n470 n469 vdd vdd PMOD W=20u L=1u
CL470 n470 0 0.01p
Mn471 n471 n470 0 0 NMOD W=10u L=1u
Mp471 n471 n470 vdd vdd PMOD W=20u L=1u
CL471 n471 0 0.01p
Mn472 n472 n471 0 0 NMOD W=10u L=1u
Mp472 n472 n471 vdd vdd PMOD W=20u L=1u
CL472 n472 0 0.01p
Mn473 n473 n472 0 0 NMOD W=10u L=1u
Mp473 n473 n472 vdd vdd PMOD W=20u L=1u
CL473 n473 0 0.01p
Mn474 n474 n473 0 0 NMOD W=10u L=1u
Mp474 n474 n473 vdd vdd PMOD W=20u L=1u
CL474 n474 0 0.01p
Mn475 n475 n474 0 0 NMOD W=10u L=1u
Mp475 n475 n474 vdd vdd PMOD W=20u L=1u
CL475 n475 0 0.01p
Mn476 n476 n475 0 0 NMOD W=10u L=1u
Mp476 n476 n475 vdd vdd PMOD W=20u L=1u
CL476 n476 0 0.01p
Mn477 n477 n476 0 0 NMOD W=10u L=1u
Mp477 n477 n476 vdd vdd PMOD W=20u L=1u
CL477 n477 0 0.01p
Mn478 n478 n477 0 0 NMOD W=10u L=1u
Mp478 n478 n477 vdd vdd PMOD W=20u L=1u
CL478 n478 0 0.01p
Mn479 n479 n478 0 0 NMOD W=10u L=1u
Mp479 n479 n478 vdd vdd PMOD W=20u L=1u
CL479 n479 0 0.01p
Mn480 n480 n479 0 0 NMOD W=10u L=1u
Mp480 n480 n479 vdd vdd PMOD W=20u L=1u
CL480 n480 0 0.01p
Mn481 n481 n480 0 0 NMOD W=10u L=1u
Mp481 n481 n480 vdd vdd PMOD W=20u L=1u
CL481 n481 0 0.01p
Mn482 n482 n481 0 0 NMOD W=10u L=1u
Mp482 n482 n481 vdd vdd PMOD W=20u L=1u
CL482 n482 0 0.01p
Mn483 n483 n482 0 0 NMOD W=10u L=1u
Mp483 n483 n482 vdd vdd PMOD W=20u L=1u
CL483 n483 0 0.01p
Mn484 n484 n483 0 0 NMOD W=10u L=1u
Mp484 n484 n483 vdd vdd PMOD W=20u L=1u
CL484 n484 0 0.01p
Mn485 n485 n484 0 0 NMOD W=10u L=1u
Mp485 n485 n484 vdd vdd PMOD W=20u L=1u
CL485 n485 0 0.01p
Mn486 n486 n485 0 0 NMOD W=10u L=1u
Mp486 n486 n485 vdd vdd PMOD W=20u L=1u
CL486 n486 0 0.01p
Mn487 n487 n486 0 0 NMOD W=10u L=1u
Mp487 n487 n486 vdd vdd PMOD W=20u L=1u
CL487 n487 0 0.01p
Mn488 n488 n487 0 0 NMOD W=10u L=1u
Mp488 n488 n487 vdd vdd PMOD W=20u L=1u
CL488 n488 0 0.01p
Mn489 n489 n488 0 0 NMOD W=10u L=1u
Mp489 n489 n488 vdd vdd PMOD W=20u L=1u
CL489 n489 0 0.01p
Mn490 n490 n489 0 0 NMOD W=10u L=1u
Mp490 n490 n489 vdd vdd PMOD W=20u L=1u
CL490 n490 0 0.01p
Mn491 n491 n490 0 0 NMOD W=10u L=1u
Mp491 n491 n490 vdd vdd PMOD W=20u L=1u
CL491 n491 0 0.01p
Mn492 n492 n491 0 0 NMOD W=10u L=1u
Mp492 n492 n491 vdd vdd PMOD W=20u L=1u
CL492 n492 0 0.01p
Mn493 n493 n492 0 0 NMOD W=10u L=1u
Mp493 n493 n492 vdd vdd PMOD W=20u L=1u
CL493 n493 0 0.01p
Mn494 n494 n493 0 0 NMOD W=10u L=1u
Mp494 n494 n493 vdd vdd PMOD W=20u L=1u
CL494 n494 0 0.01p
Mn495 n495 n494 0 0 NMOD W=10u L=1u
Mp495 n495 n494 vdd vdd PMOD W=20u L=1u
CL495 n495 0 0.01p
Mn496 n496 n495 0 0 NMOD W=10u L=1u
Mp496 n496 n495 vdd vdd PMOD W=20u L=1u
CL496 n496 0 0.01p
Mn497 n497 n496 0 0 NMOD W=10u L=1u
Mp497 n497 n496 vdd vdd PMOD W=20u L=1u
CL497 n497 0 0.01p
Mn498 n498 n497 0 0 NMOD W=10u L=1u
Mp498 n498 n497 vdd vdd PMOD W=20u L=1u
CL498 n498 0 0.01p
Mn499 n499 n498 0 0 NMOD W=10u L=1u
Mp499 n499 n498 vdd vdd PMOD W=20u L=1u
CL499 n499 0 0.01p
Mn500 n500 n499 0 0 NMOD W=10u L=1u
Mp500 n500 n499 vdd vdd PMOD W=20u L=1u
CL500 n500 0 0.01p

.TRAN 0.1n 100n
.END
