* Diode Ladder — 50 diodes in series
V1 in 0 DC 5

.MODEL DMOD D (IS=1e-14 N=1 BV=100 RS=10)

D1 in n1 DMOD
D2 n1 n2 DMOD
D3 n2 n3 DMOD
D4 n3 n4 DMOD
D5 n4 n5 DMOD
D6 n5 n6 DMOD
D7 n6 n7 DMOD
D8 n7 n8 DMOD
D9 n8 n9 DMOD
D10 n9 n10 DMOD
D11 n10 n11 DMOD
D12 n11 n12 DMOD
D13 n12 n13 DMOD
D14 n13 n14 DMOD
D15 n14 n15 DMOD
D16 n15 n16 DMOD
D17 n16 n17 DMOD
D18 n17 n18 DMOD
D19 n18 n19 DMOD
D20 n19 n20 DMOD
D21 n20 n21 DMOD
D22 n21 n22 DMOD
D23 n22 n23 DMOD
D24 n23 n24 DMOD
D25 n24 n25 DMOD
D26 n25 n26 DMOD
D27 n26 n27 DMOD
D28 n27 n28 DMOD
D29 n28 n29 DMOD
D30 n29 n30 DMOD
D31 n30 n31 DMOD
D32 n31 n32 DMOD
D33 n32 n33 DMOD
D34 n33 n34 DMOD
D35 n34 n35 DMOD
D36 n35 n36 DMOD
D37 n36 n37 DMOD
D38 n37 n38 DMOD
D39 n38 n39 DMOD
D40 n39 n40 DMOD
D41 n40 n41 DMOD
D42 n41 n42 DMOD
D43 n42 n43 DMOD
D44 n43 n44 DMOD
D45 n44 n45 DMOD
D46 n45 n46 DMOD
D47 n46 n47 DMOD
D48 n47 n48 DMOD
D49 n48 n49 DMOD
D50 n49 out DMOD

RLOAD out 0 1k

.OP
.DC V1 0 10 0.1
.END
