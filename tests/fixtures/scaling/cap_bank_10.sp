* Capacitor Bank — 10 parallel caps
V1 in 0 PULSE(0 5 0 1n 1n 1u 2u)
RS in bus 10

C1 bus 0 1p
C2 bus 0 1p
C3 bus 0 1p
C4 bus 0 1p
C5 bus 0 1p
C6 bus 0 1p
C7 bus 0 1p
C8 bus 0 1p
C9 bus 0 1p
C10 bus 0 1p
RL1 bus 0 1MEG
RL2 bus 0 1MEG
RL3 bus 0 1MEG
RL4 bus 0 1MEG
RL5 bus 0 1MEG
RL6 bus 0 1MEG
RL7 bus 0 1MEG
RL8 bus 0 1MEG
RL9 bus 0 1MEG
RL10 bus 0 1MEG

.TRAN 0.1n 5u
.END
