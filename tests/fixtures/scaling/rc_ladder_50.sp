* RC Ladder — 50 stages
V1 1 0 PULSE(0 1 0 1n 1n 1u 2u)
R1 1 2 1k
R2 2 3 1k
R3 3 4 1k
R4 4 5 1k
R5 5 6 1k
R6 6 7 1k
R7 7 8 1k
R8 8 9 1k
R9 9 10 1k
R10 10 11 1k
R11 11 12 1k
R12 12 13 1k
R13 13 14 1k
R14 14 15 1k
R15 15 16 1k
R16 16 17 1k
R17 17 18 1k
R18 18 19 1k
R19 19 20 1k
R20 20 21 1k
R21 21 22 1k
R22 22 23 1k
R23 23 24 1k
R24 24 25 1k
R25 25 26 1k
R26 26 27 1k
R27 27 28 1k
R28 28 29 1k
R29 29 30 1k
R30 30 31 1k
R31 31 32 1k
R32 32 33 1k
R33 33 34 1k
R34 34 35 1k
R35 35 36 1k
R36 36 37 1k
R37 37 38 1k
R38 38 39 1k
R39 39 40 1k
R40 40 41 1k
R41 41 42 1k
R42 42 43 1k
R43 43 44 1k
R44 44 45 1k
R45 45 46 1k
R46 46 47 1k
R47 47 48 1k
R48 48 49 1k
R49 49 50 1k
R50 50 51 1k
C1 2 0 1p
C2 3 0 1p
C3 4 0 1p
C4 5 0 1p
C5 6 0 1p
C6 7 0 1p
C7 8 0 1p
C8 9 0 1p
C9 10 0 1p
C10 11 0 1p
C11 12 0 1p
C12 13 0 1p
C13 14 0 1p
C14 15 0 1p
C15 16 0 1p
C16 17 0 1p
C17 18 0 1p
C18 19 0 1p
C19 20 0 1p
C20 21 0 1p
C21 22 0 1p
C22 23 0 1p
C23 24 0 1p
C24 25 0 1p
C25 26 0 1p
C26 27 0 1p
C27 28 0 1p
C28 29 0 1p
C29 30 0 1p
C30 31 0 1p
C31 32 0 1p
C32 33 0 1p
C33 34 0 1p
C34 35 0 1p
C35 36 0 1p
C36 37 0 1p
C37 38 0 1p
C38 39 0 1p
C39 40 0 1p
C40 41 0 1p
C41 42 0 1p
C42 43 0 1p
C43 44 0 1p
C44 45 0 1p
C45 46 0 1p
C46 47 0 1p
C47 48 0 1p
C48 49 0 1p
C49 50 0 1p
C50 51 0 1p
.TRAN 0.1n 10u
.END
