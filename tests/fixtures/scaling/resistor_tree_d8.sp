* Resistor Binary Tree — depth 8 (511 nodes)
V1 n1 0 DC 1

R1 n1 n2 1k
R2 n1 n3 1k
R3 n2 n4 1k
R4 n2 n5 1k
R5 n3 n6 1k
R6 n3 n7 1k
R7 n4 n8 1k
R8 n4 n9 1k
R9 n5 n10 1k
R10 n5 n11 1k
R11 n6 n12 1k
R12 n6 n13 1k
R13 n7 n14 1k
R14 n7 n15 1k
R15 n8 n16 1k
R16 n8 n17 1k
R17 n9 n18 1k
R18 n9 n19 1k
R19 n10 n20 1k
R20 n10 n21 1k
R21 n11 n22 1k
R22 n11 n23 1k
R23 n12 n24 1k
R24 n12 n25 1k
R25 n13 n26 1k
R26 n13 n27 1k
R27 n14 n28 1k
R28 n14 n29 1k
R29 n15 n30 1k
R30 n15 n31 1k
R31 n16 n32 1k
R32 n16 n33 1k
R33 n17 n34 1k
R34 n17 n35 1k
R35 n18 n36 1k
R36 n18 n37 1k
R37 n19 n38 1k
R38 n19 n39 1k
R39 n20 n40 1k
R40 n20 n41 1k
R41 n21 n42 1k
R42 n21 n43 1k
R43 n22 n44 1k
R44 n22 n45 1k
R45 n23 n46 1k
R46 n23 n47 1k
R47 n24 n48 1k
R48 n24 n49 1k
R49 n25 n50 1k
R50 n25 n51 1k
R51 n26 n52 1k
R52 n26 n53 1k
R53 n27 n54 1k
R54 n27 n55 1k
R55 n28 n56 1k
R56 n28 n57 1k
R57 n29 n58 1k
R58 n29 n59 1k
R59 n30 n60 1k
R60 n30 n61 1k
R61 n31 n62 1k
R62 n31 n63 1k
R63 n32 n64 1k
R64 n32 n65 1k
R65 n33 n66 1k
R66 n33 n67 1k
R67 n34 n68 1k
R68 n34 n69 1k
R69 n35 n70 1k
R70 n35 n71 1k
R71 n36 n72 1k
R72 n36 n73 1k
R73 n37 n74 1k
R74 n37 n75 1k
R75 n38 n76 1k
R76 n38 n77 1k
R77 n39 n78 1k
R78 n39 n79 1k
R79 n40 n80 1k
R80 n40 n81 1k
R81 n41 n82 1k
R82 n41 n83 1k
R83 n42 n84 1k
R84 n42 n85 1k
R85 n43 n86 1k
R86 n43 n87 1k
R87 n44 n88 1k
R88 n44 n89 1k
R89 n45 n90 1k
R90 n45 n91 1k
R91 n46 n92 1k
R92 n46 n93 1k
R93 n47 n94 1k
R94 n47 n95 1k
R95 n48 n96 1k
R96 n48 n97 1k
R97 n49 n98 1k
R98 n49 n99 1k
R99 n50 n100 1k
R100 n50 n101 1k
R101 n51 n102 1k
R102 n51 n103 1k
R103 n52 n104 1k
R104 n52 n105 1k
R105 n53 n106 1k
R106 n53 n107 1k
R107 n54 n108 1k
R108 n54 n109 1k
R109 n55 n110 1k
R110 n55 n111 1k
R111 n56 n112 1k
R112 n56 n113 1k
R113 n57 n114 1k
R114 n57 n115 1k
R115 n58 n116 1k
R116 n58 n117 1k
R117 n59 n118 1k
R118 n59 n119 1k
R119 n60 n120 1k
R120 n60 n121 1k
R121 n61 n122 1k
R122 n61 n123 1k
R123 n62 n124 1k
R124 n62 n125 1k
R125 n63 n126 1k
R126 n63 n127 1k
R127 n64 n128 1k
R128 n64 n129 1k
R129 n65 n130 1k
R130 n65 n131 1k
R131 n66 n132 1k
R132 n66 n133 1k
R133 n67 n134 1k
R134 n67 n135 1k
R135 n68 n136 1k
R136 n68 n137 1k
R137 n69 n138 1k
R138 n69 n139 1k
R139 n70 n140 1k
R140 n70 n141 1k
R141 n71 n142 1k
R142 n71 n143 1k
R143 n72 n144 1k
R144 n72 n145 1k
R145 n73 n146 1k
R146 n73 n147 1k
R147 n74 n148 1k
R148 n74 n149 1k
R149 n75 n150 1k
R150 n75 n151 1k
R151 n76 n152 1k
R152 n76 n153 1k
R153 n77 n154 1k
R154 n77 n155 1k
R155 n78 n156 1k
R156 n78 n157 1k
R157 n79 n158 1k
R158 n79 n159 1k
R159 n80 n160 1k
R160 n80 n161 1k
R161 n81 n162 1k
R162 n81 n163 1k
R163 n82 n164 1k
R164 n82 n165 1k
R165 n83 n166 1k
R166 n83 n167 1k
R167 n84 n168 1k
R168 n84 n169 1k
R169 n85 n170 1k
R170 n85 n171 1k
R171 n86 n172 1k
R172 n86 n173 1k
R173 n87 n174 1k
R174 n87 n175 1k
R175 n88 n176 1k
R176 n88 n177 1k
R177 n89 n178 1k
R178 n89 n179 1k
R179 n90 n180 1k
R180 n90 n181 1k
R181 n91 n182 1k
R182 n91 n183 1k
R183 n92 n184 1k
R184 n92 n185 1k
R185 n93 n186 1k
R186 n93 n187 1k
R187 n94 n188 1k
R188 n94 n189 1k
R189 n95 n190 1k
R190 n95 n191 1k
R191 n96 n192 1k
R192 n96 n193 1k
R193 n97 n194 1k
R194 n97 n195 1k
R195 n98 n196 1k
R196 n98 n197 1k
R197 n99 n198 1k
R198 n99 n199 1k
R199 n100 n200 1k
R200 n100 n201 1k
R201 n101 n202 1k
R202 n101 n203 1k
R203 n102 n204 1k
R204 n102 n205 1k
R205 n103 n206 1k
R206 n103 n207 1k
R207 n104 n208 1k
R208 n104 n209 1k
R209 n105 n210 1k
R210 n105 n211 1k
R211 n106 n212 1k
R212 n106 n213 1k
R213 n107 n214 1k
R214 n107 n215 1k
R215 n108 n216 1k
R216 n108 n217 1k
R217 n109 n218 1k
R218 n109 n219 1k
R219 n110 n220 1k
R220 n110 n221 1k
R221 n111 n222 1k
R222 n111 n223 1k
R223 n112 n224 1k
R224 n112 n225 1k
R225 n113 n226 1k
R226 n113 n227 1k
R227 n114 n228 1k
R228 n114 n229 1k
R229 n115 n230 1k
R230 n115 n231 1k
R231 n116 n232 1k
R232 n116 n233 1k
R233 n117 n234 1k
R234 n117 n235 1k
R235 n118 n236 1k
R236 n118 n237 1k
R237 n119 n238 1k
R238 n119 n239 1k
R239 n120 n240 1k
R240 n120 n241 1k
R241 n121 n242 1k
R242 n121 n243 1k
R243 n122 n244 1k
R244 n122 n245 1k
R245 n123 n246 1k
R246 n123 n247 1k
R247 n124 n248 1k
R248 n124 n249 1k
R249 n125 n250 1k
R250 n125 n251 1k
R251 n126 n252 1k
R252 n126 n253 1k
R253 n127 n254 1k
R254 n127 n255 1k
R255 n128 n256 1k
R256 n128 n257 1k
R257 n129 n258 1k
R258 n129 n259 1k
R259 n130 n260 1k
R260 n130 n261 1k
R261 n131 n262 1k
R262 n131 n263 1k
R263 n132 n264 1k
R264 n132 n265 1k
R265 n133 n266 1k
R266 n133 n267 1k
R267 n134 n268 1k
R268 n134 n269 1k
R269 n135 n270 1k
R270 n135 n271 1k
R271 n136 n272 1k
R272 n136 n273 1k
R273 n137 n274 1k
R274 n137 n275 1k
R275 n138 n276 1k
R276 n138 n277 1k
R277 n139 n278 1k
R278 n139 n279 1k
R279 n140 n280 1k
R280 n140 n281 1k
R281 n141 n282 1k
R282 n141 n283 1k
R283 n142 n284 1k
R284 n142 n285 1k
R285 n143 n286 1k
R286 n143 n287 1k
R287 n144 n288 1k
R288 n144 n289 1k
R289 n145 n290 1k
R290 n145 n291 1k
R291 n146 n292 1k
R292 n146 n293 1k
R293 n147 n294 1k
R294 n147 n295 1k
R295 n148 n296 1k
R296 n148 n297 1k
R297 n149 n298 1k
R298 n149 n299 1k
R299 n150 n300 1k
R300 n150 n301 1k
R301 n151 n302 1k
R302 n151 n303 1k
R303 n152 n304 1k
R304 n152 n305 1k
R305 n153 n306 1k
R306 n153 n307 1k
R307 n154 n308 1k
R308 n154 n309 1k
R309 n155 n310 1k
R310 n155 n311 1k
R311 n156 n312 1k
R312 n156 n313 1k
R313 n157 n314 1k
R314 n157 n315 1k
R315 n158 n316 1k
R316 n158 n317 1k
R317 n159 n318 1k
R318 n159 n319 1k
R319 n160 n320 1k
R320 n160 n321 1k
R321 n161 n322 1k
R322 n161 n323 1k
R323 n162 n324 1k
R324 n162 n325 1k
R325 n163 n326 1k
R326 n163 n327 1k
R327 n164 n328 1k
R328 n164 n329 1k
R329 n165 n330 1k
R330 n165 n331 1k
R331 n166 n332 1k
R332 n166 n333 1k
R333 n167 n334 1k
R334 n167 n335 1k
R335 n168 n336 1k
R336 n168 n337 1k
R337 n169 n338 1k
R338 n169 n339 1k
R339 n170 n340 1k
R340 n170 n341 1k
R341 n171 n342 1k
R342 n171 n343 1k
R343 n172 n344 1k
R344 n172 n345 1k
R345 n173 n346 1k
R346 n173 n347 1k
R347 n174 n348 1k
R348 n174 n349 1k
R349 n175 n350 1k
R350 n175 n351 1k
R351 n176 n352 1k
R352 n176 n353 1k
R353 n177 n354 1k
R354 n177 n355 1k
R355 n178 n356 1k
R356 n178 n357 1k
R357 n179 n358 1k
R358 n179 n359 1k
R359 n180 n360 1k
R360 n180 n361 1k
R361 n181 n362 1k
R362 n181 n363 1k
R363 n182 n364 1k
R364 n182 n365 1k
R365 n183 n366 1k
R366 n183 n367 1k
R367 n184 n368 1k
R368 n184 n369 1k
R369 n185 n370 1k
R370 n185 n371 1k
R371 n186 n372 1k
R372 n186 n373 1k
R373 n187 n374 1k
R374 n187 n375 1k
R375 n188 n376 1k
R376 n188 n377 1k
R377 n189 n378 1k
R378 n189 n379 1k
R379 n190 n380 1k
R380 n190 n381 1k
R381 n191 n382 1k
R382 n191 n383 1k
R383 n192 n384 1k
R384 n192 n385 1k
R385 n193 n386 1k
R386 n193 n387 1k
R387 n194 n388 1k
R388 n194 n389 1k
R389 n195 n390 1k
R390 n195 n391 1k
R391 n196 n392 1k
R392 n196 n393 1k
R393 n197 n394 1k
R394 n197 n395 1k
R395 n198 n396 1k
R396 n198 n397 1k
R397 n199 n398 1k
R398 n199 n399 1k
R399 n200 n400 1k
R400 n200 n401 1k
R401 n201 n402 1k
R402 n201 n403 1k
R403 n202 n404 1k
R404 n202 n405 1k
R405 n203 n406 1k
R406 n203 n407 1k
R407 n204 n408 1k
R408 n204 n409 1k
R409 n205 n410 1k
R410 n205 n411 1k
R411 n206 n412 1k
R412 n206 n413 1k
R413 n207 n414 1k
R414 n207 n415 1k
R415 n208 n416 1k
R416 n208 n417 1k
R417 n209 n418 1k
R418 n209 n419 1k
R419 n210 n420 1k
R420 n210 n421 1k
R421 n211 n422 1k
R422 n211 n423 1k
R423 n212 n424 1k
R424 n212 n425 1k
R425 n213 n426 1k
R426 n213 n427 1k
R427 n214 n428 1k
R428 n214 n429 1k
R429 n215 n430 1k
R430 n215 n431 1k
R431 n216 n432 1k
R432 n216 n433 1k
R433 n217 n434 1k
R434 n217 n435 1k
R435 n218 n436 1k
R436 n218 n437 1k
R437 n219 n438 1k
R438 n219 n439 1k
R439 n220 n440 1k
R440 n220 n441 1k
R441 n221 n442 1k
R442 n221 n443 1k
R443 n222 n444 1k
R444 n222 n445 1k
R445 n223 n446 1k
R446 n223 n447 1k
R447 n224 n448 1k
R448 n224 n449 1k
R449 n225 n450 1k
R450 n225 n451 1k
R451 n226 n452 1k
R452 n226 n453 1k
R453 n227 n454 1k
R454 n227 n455 1k
R455 n228 n456 1k
R456 n228 n457 1k
R457 n229 n458 1k
R458 n229 n459 1k
R459 n230 n460 1k
R460 n230 n461 1k
R461 n231 n462 1k
R462 n231 n463 1k
R463 n232 n464 1k
R464 n232 n465 1k
R465 n233 n466 1k
R466 n233 n467 1k
R467 n234 n468 1k
R468 n234 n469 1k
R469 n235 n470 1k
R470 n235 n471 1k
R471 n236 n472 1k
R472 n236 n473 1k
R473 n237 n474 1k
R474 n237 n475 1k
R475 n238 n476 1k
R476 n238 n477 1k
R477 n239 n478 1k
R478 n239 n479 1k
R479 n240 n480 1k
R480 n240 n481 1k
R481 n241 n482 1k
R482 n241 n483 1k
R483 n242 n484 1k
R484 n242 n485 1k
R485 n243 n486 1k
R486 n243 n487 1k
R487 n244 n488 1k
R488 n244 n489 1k
R489 n245 n490 1k
R490 n245 n491 1k
R491 n246 n492 1k
R492 n246 n493 1k
R493 n247 n494 1k
R494 n247 n495 1k
R495 n248 n496 1k
R496 n248 n497 1k
R497 n249 n498 1k
R498 n249 n499 1k
R499 n250 n500 1k
R500 n250 n501 1k
R501 n251 n502 1k
R502 n251 n503 1k
R503 n252 n504 1k
R504 n252 n505 1k
R505 n253 n506 1k
R506 n253 n507 1k
R507 n254 n508 1k
R508 n254 n509 1k
R509 n255 n510 1k
R510 n255 n511 1k
R511 n256 0 1k
R512 n257 0 1k
R513 n258 0 1k
R514 n259 0 1k
R515 n260 0 1k
R516 n261 0 1k
R517 n262 0 1k
R518 n263 0 1k
R519 n264 0 1k
R520 n265 0 1k
R521 n266 0 1k
R522 n267 0 1k
R523 n268 0 1k
R524 n269 0 1k
R525 n270 0 1k
R526 n271 0 1k
R527 n272 0 1k
R528 n273 0 1k
R529 n274 0 1k
R530 n275 0 1k
R531 n276 0 1k
R532 n277 0 1k
R533 n278 0 1k
R534 n279 0 1k
R535 n280 0 1k
R536 n281 0 1k
R537 n282 0 1k
R538 n283 0 1k
R539 n284 0 1k
R540 n285 0 1k
R541 n286 0 1k
R542 n287 0 1k
R543 n288 0 1k
R544 n289 0 1k
R545 n290 0 1k
R546 n291 0 1k
R547 n292 0 1k
R548 n293 0 1k
R549 n294 0 1k
R550 n295 0 1k
R551 n296 0 1k
R552 n297 0 1k
R553 n298 0 1k
R554 n299 0 1k
R555 n300 0 1k
R556 n301 0 1k
R557 n302 0 1k
R558 n303 0 1k
R559 n304 0 1k
R560 n305 0 1k
R561 n306 0 1k
R562 n307 0 1k
R563 n308 0 1k
R564 n309 0 1k
R565 n310 0 1k
R566 n311 0 1k
R567 n312 0 1k
R568 n313 0 1k
R569 n314 0 1k
R570 n315 0 1k
R571 n316 0 1k
R572 n317 0 1k
R573 n318 0 1k
R574 n319 0 1k
R575 n320 0 1k
R576 n321 0 1k
R577 n322 0 1k
R578 n323 0 1k
R579 n324 0 1k
R580 n325 0 1k
R581 n326 0 1k
R582 n327 0 1k
R583 n328 0 1k
R584 n329 0 1k
R585 n330 0 1k
R586 n331 0 1k
R587 n332 0 1k
R588 n333 0 1k
R589 n334 0 1k
R590 n335 0 1k
R591 n336 0 1k
R592 n337 0 1k
R593 n338 0 1k
R594 n339 0 1k
R595 n340 0 1k
R596 n341 0 1k
R597 n342 0 1k
R598 n343 0 1k
R599 n344 0 1k
R600 n345 0 1k
R601 n346 0 1k
R602 n347 0 1k
R603 n348 0 1k
R604 n349 0 1k
R605 n350 0 1k
R606 n351 0 1k
R607 n352 0 1k
R608 n353 0 1k
R609 n354 0 1k
R610 n355 0 1k
R611 n356 0 1k
R612 n357 0 1k
R613 n358 0 1k
R614 n359 0 1k
R615 n360 0 1k
R616 n361 0 1k
R617 n362 0 1k
R618 n363 0 1k
R619 n364 0 1k
R620 n365 0 1k
R621 n366 0 1k
R622 n367 0 1k
R623 n368 0 1k
R624 n369 0 1k
R625 n370 0 1k
R626 n371 0 1k
R627 n372 0 1k
R628 n373 0 1k
R629 n374 0 1k
R630 n375 0 1k
R631 n376 0 1k
R632 n377 0 1k
R633 n378 0 1k
R634 n379 0 1k
R635 n380 0 1k
R636 n381 0 1k
R637 n382 0 1k
R638 n383 0 1k
R639 n384 0 1k
R640 n385 0 1k
R641 n386 0 1k
R642 n387 0 1k
R643 n388 0 1k
R644 n389 0 1k
R645 n390 0 1k
R646 n391 0 1k
R647 n392 0 1k
R648 n393 0 1k
R649 n394 0 1k
R650 n395 0 1k
R651 n396 0 1k
R652 n397 0 1k
R653 n398 0 1k
R654 n399 0 1k
R655 n400 0 1k
R656 n401 0 1k
R657 n402 0 1k
R658 n403 0 1k
R659 n404 0 1k
R660 n405 0 1k
R661 n406 0 1k
R662 n407 0 1k
R663 n408 0 1k
R664 n409 0 1k
R665 n410 0 1k
R666 n411 0 1k
R667 n412 0 1k
R668 n413 0 1k
R669 n414 0 1k
R670 n415 0 1k
R671 n416 0 1k
R672 n417 0 1k
R673 n418 0 1k
R674 n419 0 1k
R675 n420 0 1k
R676 n421 0 1k
R677 n422 0 1k
R678 n423 0 1k
R679 n424 0 1k
R680 n425 0 1k
R681 n426 0 1k
R682 n427 0 1k
R683 n428 0 1k
R684 n429 0 1k
R685 n430 0 1k
R686 n431 0 1k
R687 n432 0 1k
R688 n433 0 1k
R689 n434 0 1k
R690 n435 0 1k
R691 n436 0 1k
R692 n437 0 1k
R693 n438 0 1k
R694 n439 0 1k
R695 n440 0 1k
R696 n441 0 1k
R697 n442 0 1k
R698 n443 0 1k
R699 n444 0 1k
R700 n445 0 1k
R701 n446 0 1k
R702 n447 0 1k
R703 n448 0 1k
R704 n449 0 1k
R705 n450 0 1k
R706 n451 0 1k
R707 n452 0 1k
R708 n453 0 1k
R709 n454 0 1k
R710 n455 0 1k
R711 n456 0 1k
R712 n457 0 1k
R713 n458 0 1k
R714 n459 0 1k
R715 n460 0 1k
R716 n461 0 1k
R717 n462 0 1k
R718 n463 0 1k
R719 n464 0 1k
R720 n465 0 1k
R721 n466 0 1k
R722 n467 0 1k
R723 n468 0 1k
R724 n469 0 1k
R725 n470 0 1k
R726 n471 0 1k
R727 n472 0 1k
R728 n473 0 1k
R729 n474 0 1k
R730 n475 0 1k
R731 n476 0 1k
R732 n477 0 1k
R733 n478 0 1k
R734 n479 0 1k
R735 n480 0 1k
R736 n481 0 1k
R737 n482 0 1k
R738 n483 0 1k
R739 n484 0 1k
R740 n485 0 1k
R741 n486 0 1k
R742 n487 0 1k
R743 n488 0 1k
R744 n489 0 1k
R745 n490 0 1k
R746 n491 0 1k
R747 n492 0 1k
R748 n493 0 1k
R749 n494 0 1k
R750 n495 0 1k
R751 n496 0 1k
R752 n497 0 1k
R753 n498 0 1k
R754 n499 0 1k
R755 n500 0 1k
R756 n501 0 1k
R757 n502 0 1k
R758 n503 0 1k
R759 n504 0 1k
R760 n505 0 1k
R761 n506 0 1k
R762 n507 0 1k
R763 n508 0 1k
R764 n509 0 1k
R765 n510 0 1k
R766 n511 0 1k

.OP
.END
