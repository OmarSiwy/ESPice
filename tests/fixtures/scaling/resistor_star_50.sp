* Resistor Star Network — 50 branches
V1 center 0 DC 1

R1 center node_1 1k
R2 center node_2 1k
R3 center node_3 1k
R4 center node_4 1k
R5 center node_5 1k
R6 center node_6 1k
R7 center node_7 1k
R8 center node_8 1k
R9 center node_9 1k
R10 center node_10 1k
R11 center node_11 1k
R12 center node_12 1k
R13 center node_13 1k
R14 center node_14 1k
R15 center node_15 1k
R16 center node_16 1k
R17 center node_17 1k
R18 center node_18 1k
R19 center node_19 1k
R20 center node_20 1k
R21 center node_21 1k
R22 center node_22 1k
R23 center node_23 1k
R24 center node_24 1k
R25 center node_25 1k
R26 center node_26 1k
R27 center node_27 1k
R28 center node_28 1k
R29 center node_29 1k
R30 center node_30 1k
R31 center node_31 1k
R32 center node_32 1k
R33 center node_33 1k
R34 center node_34 1k
R35 center node_35 1k
R36 center node_36 1k
R37 center node_37 1k
R38 center node_38 1k
R39 center node_39 1k
R40 center node_40 1k
R41 center node_41 1k
R42 center node_42 1k
R43 center node_43 1k
R44 center node_44 1k
R45 center node_45 1k
R46 center node_46 1k
R47 center node_47 1k
R48 center node_48 1k
R49 center node_49 1k
R50 center node_50 1k
RG1 node_1 0 1k
RG2 node_2 0 1k
RG3 node_3 0 1k
RG4 node_4 0 1k
RG5 node_5 0 1k
RG6 node_6 0 1k
RG7 node_7 0 1k
RG8 node_8 0 1k
RG9 node_9 0 1k
RG10 node_10 0 1k
RG11 node_11 0 1k
RG12 node_12 0 1k
RG13 node_13 0 1k
RG14 node_14 0 1k
RG15 node_15 0 1k
RG16 node_16 0 1k
RG17 node_17 0 1k
RG18 node_18 0 1k
RG19 node_19 0 1k
RG20 node_20 0 1k
RG21 node_21 0 1k
RG22 node_22 0 1k
RG23 node_23 0 1k
RG24 node_24 0 1k
RG25 node_25 0 1k
RG26 node_26 0 1k
RG27 node_27 0 1k
RG28 node_28 0 1k
RG29 node_29 0 1k
RG30 node_30 0 1k
RG31 node_31 0 1k
RG32 node_32 0 1k
RG33 node_33 0 1k
RG34 node_34 0 1k
RG35 node_35 0 1k
RG36 node_36 0 1k
RG37 node_37 0 1k
RG38 node_38 0 1k
RG39 node_39 0 1k
RG40 node_40 0 1k
RG41 node_41 0 1k
RG42 node_42 0 1k
RG43 node_43 0 1k
RG44 node_44 0 1k
RG45 node_45 0 1k
RG46 node_46 0 1k
RG47 node_47 0 1k
RG48 node_48 0 1k
RG49 node_49 0 1k
RG50 node_50 0 1k

.OP
.END
