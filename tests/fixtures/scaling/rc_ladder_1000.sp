* RC Ladder — 1000 stages
V1 1 0 PULSE(0 1 0 1n 1n 1u 2u)
R1 1 2 1k
R2 2 3 1k
R3 3 4 1k
R4 4 5 1k
R5 5 6 1k
R6 6 7 1k
R7 7 8 1k
R8 8 9 1k
R9 9 10 1k
R10 10 11 1k
R11 11 12 1k
R12 12 13 1k
R13 13 14 1k
R14 14 15 1k
R15 15 16 1k
R16 16 17 1k
R17 17 18 1k
R18 18 19 1k
R19 19 20 1k
R20 20 21 1k
R21 21 22 1k
R22 22 23 1k
R23 23 24 1k
R24 24 25 1k
R25 25 26 1k
R26 26 27 1k
R27 27 28 1k
R28 28 29 1k
R29 29 30 1k
R30 30 31 1k
R31 31 32 1k
R32 32 33 1k
R33 33 34 1k
R34 34 35 1k
R35 35 36 1k
R36 36 37 1k
R37 37 38 1k
R38 38 39 1k
R39 39 40 1k
R40 40 41 1k
R41 41 42 1k
R42 42 43 1k
R43 43 44 1k
R44 44 45 1k
R45 45 46 1k
R46 46 47 1k
R47 47 48 1k
R48 48 49 1k
R49 49 50 1k
R50 50 51 1k
R51 51 52 1k
R52 52 53 1k
R53 53 54 1k
R54 54 55 1k
R55 55 56 1k
R56 56 57 1k
R57 57 58 1k
R58 58 59 1k
R59 59 60 1k
R60 60 61 1k
R61 61 62 1k
R62 62 63 1k
R63 63 64 1k
R64 64 65 1k
R65 65 66 1k
R66 66 67 1k
R67 67 68 1k
R68 68 69 1k
R69 69 70 1k
R70 70 71 1k
R71 71 72 1k
R72 72 73 1k
R73 73 74 1k
R74 74 75 1k
R75 75 76 1k
R76 76 77 1k
R77 77 78 1k
R78 78 79 1k
R79 79 80 1k
R80 80 81 1k
R81 81 82 1k
R82 82 83 1k
R83 83 84 1k
R84 84 85 1k
R85 85 86 1k
R86 86 87 1k
R87 87 88 1k
R88 88 89 1k
R89 89 90 1k
R90 90 91 1k
R91 91 92 1k
R92 92 93 1k
R93 93 94 1k
R94 94 95 1k
R95 95 96 1k
R96 96 97 1k
R97 97 98 1k
R98 98 99 1k
R99 99 100 1k
R100 100 101 1k
R101 101 102 1k
R102 102 103 1k
R103 103 104 1k
R104 104 105 1k
R105 105 106 1k
R106 106 107 1k
R107 107 108 1k
R108 108 109 1k
R109 109 110 1k
R110 110 111 1k
R111 111 112 1k
R112 112 113 1k
R113 113 114 1k
R114 114 115 1k
R115 115 116 1k
R116 116 117 1k
R117 117 118 1k
R118 118 119 1k
R119 119 120 1k
R120 120 121 1k
R121 121 122 1k
R122 122 123 1k
R123 123 124 1k
R124 124 125 1k
R125 125 126 1k
R126 126 127 1k
R127 127 128 1k
R128 128 129 1k
R129 129 130 1k
R130 130 131 1k
R131 131 132 1k
R132 132 133 1k
R133 133 134 1k
R134 134 135 1k
R135 135 136 1k
R136 136 137 1k
R137 137 138 1k
R138 138 139 1k
R139 139 140 1k
R140 140 141 1k
R141 141 142 1k
R142 142 143 1k
R143 143 144 1k
R144 144 145 1k
R145 145 146 1k
R146 146 147 1k
R147 147 148 1k
R148 148 149 1k
R149 149 150 1k
R150 150 151 1k
R151 151 152 1k
R152 152 153 1k
R153 153 154 1k
R154 154 155 1k
R155 155 156 1k
R156 156 157 1k
R157 157 158 1k
R158 158 159 1k
R159 159 160 1k
R160 160 161 1k
R161 161 162 1k
R162 162 163 1k
R163 163 164 1k
R164 164 165 1k
R165 165 166 1k
R166 166 167 1k
R167 167 168 1k
R168 168 169 1k
R169 169 170 1k
R170 170 171 1k
R171 171 172 1k
R172 172 173 1k
R173 173 174 1k
R174 174 175 1k
R175 175 176 1k
R176 176 177 1k
R177 177 178 1k
R178 178 179 1k
R179 179 180 1k
R180 180 181 1k
R181 181 182 1k
R182 182 183 1k
R183 183 184 1k
R184 184 185 1k
R185 185 186 1k
R186 186 187 1k
R187 187 188 1k
R188 188 189 1k
R189 189 190 1k
R190 190 191 1k
R191 191 192 1k
R192 192 193 1k
R193 193 194 1k
R194 194 195 1k
R195 195 196 1k
R196 196 197 1k
R197 197 198 1k
R198 198 199 1k
R199 199 200 1k
R200 200 201 1k
R201 201 202 1k
R202 202 203 1k
R203 203 204 1k
R204 204 205 1k
R205 205 206 1k
R206 206 207 1k
R207 207 208 1k
R208 208 209 1k
R209 209 210 1k
R210 210 211 1k
R211 211 212 1k
R212 212 213 1k
R213 213 214 1k
R214 214 215 1k
R215 215 216 1k
R216 216 217 1k
R217 217 218 1k
R218 218 219 1k
R219 219 220 1k
R220 220 221 1k
R221 221 222 1k
R222 222 223 1k
R223 223 224 1k
R224 224 225 1k
R225 225 226 1k
R226 226 227 1k
R227 227 228 1k
R228 228 229 1k
R229 229 230 1k
R230 230 231 1k
R231 231 232 1k
R232 232 233 1k
R233 233 234 1k
R234 234 235 1k
R235 235 236 1k
R236 236 237 1k
R237 237 238 1k
R238 238 239 1k
R239 239 240 1k
R240 240 241 1k
R241 241 242 1k
R242 242 243 1k
R243 243 244 1k
R244 244 245 1k
R245 245 246 1k
R246 246 247 1k
R247 247 248 1k
R248 248 249 1k
R249 249 250 1k
R250 250 251 1k
R251 251 252 1k
R252 252 253 1k
R253 253 254 1k
R254 254 255 1k
R255 255 256 1k
R256 256 257 1k
R257 257 258 1k
R258 258 259 1k
R259 259 260 1k
R260 260 261 1k
R261 261 262 1k
R262 262 263 1k
R263 263 264 1k
R264 264 265 1k
R265 265 266 1k
R266 266 267 1k
R267 267 268 1k
R268 268 269 1k
R269 269 270 1k
R270 270 271 1k
R271 271 272 1k
R272 272 273 1k
R273 273 274 1k
R274 274 275 1k
R275 275 276 1k
R276 276 277 1k
R277 277 278 1k
R278 278 279 1k
R279 279 280 1k
R280 280 281 1k
R281 281 282 1k
R282 282 283 1k
R283 283 284 1k
R284 284 285 1k
R285 285 286 1k
R286 286 287 1k
R287 287 288 1k
R288 288 289 1k
R289 289 290 1k
R290 290 291 1k
R291 291 292 1k
R292 292 293 1k
R293 293 294 1k
R294 294 295 1k
R295 295 296 1k
R296 296 297 1k
R297 297 298 1k
R298 298 299 1k
R299 299 300 1k
R300 300 301 1k
R301 301 302 1k
R302 302 303 1k
R303 303 304 1k
R304 304 305 1k
R305 305 306 1k
R306 306 307 1k
R307 307 308 1k
R308 308 309 1k
R309 309 310 1k
R310 310 311 1k
R311 311 312 1k
R312 312 313 1k
R313 313 314 1k
R314 314 315 1k
R315 315 316 1k
R316 316 317 1k
R317 317 318 1k
R318 318 319 1k
R319 319 320 1k
R320 320 321 1k
R321 321 322 1k
R322 322 323 1k
R323 323 324 1k
R324 324 325 1k
R325 325 326 1k
R326 326 327 1k
R327 327 328 1k
R328 328 329 1k
R329 329 330 1k
R330 330 331 1k
R331 331 332 1k
R332 332 333 1k
R333 333 334 1k
R334 334 335 1k
R335 335 336 1k
R336 336 337 1k
R337 337 338 1k
R338 338 339 1k
R339 339 340 1k
R340 340 341 1k
R341 341 342 1k
R342 342 343 1k
R343 343 344 1k
R344 344 345 1k
R345 345 346 1k
R346 346 347 1k
R347 347 348 1k
R348 348 349 1k
R349 349 350 1k
R350 350 351 1k
R351 351 352 1k
R352 352 353 1k
R353 353 354 1k
R354 354 355 1k
R355 355 356 1k
R356 356 357 1k
R357 357 358 1k
R358 358 359 1k
R359 359 360 1k
R360 360 361 1k
R361 361 362 1k
R362 362 363 1k
R363 363 364 1k
R364 364 365 1k
R365 365 366 1k
R366 366 367 1k
R367 367 368 1k
R368 368 369 1k
R369 369 370 1k
R370 370 371 1k
R371 371 372 1k
R372 372 373 1k
R373 373 374 1k
R374 374 375 1k
R375 375 376 1k
R376 376 377 1k
R377 377 378 1k
R378 378 379 1k
R379 379 380 1k
R380 380 381 1k
R381 381 382 1k
R382 382 383 1k
R383 383 384 1k
R384 384 385 1k
R385 385 386 1k
R386 386 387 1k
R387 387 388 1k
R388 388 389 1k
R389 389 390 1k
R390 390 391 1k
R391 391 392 1k
R392 392 393 1k
R393 393 394 1k
R394 394 395 1k
R395 395 396 1k
R396 396 397 1k
R397 397 398 1k
R398 398 399 1k
R399 399 400 1k
R400 400 401 1k
R401 401 402 1k
R402 402 403 1k
R403 403 404 1k
R404 404 405 1k
R405 405 406 1k
R406 406 407 1k
R407 407 408 1k
R408 408 409 1k
R409 409 410 1k
R410 410 411 1k
R411 411 412 1k
R412 412 413 1k
R413 413 414 1k
R414 414 415 1k
R415 415 416 1k
R416 416 417 1k
R417 417 418 1k
R418 418 419 1k
R419 419 420 1k
R420 420 421 1k
R421 421 422 1k
R422 422 423 1k
R423 423 424 1k
R424 424 425 1k
R425 425 426 1k
R426 426 427 1k
R427 427 428 1k
R428 428 429 1k
R429 429 430 1k
R430 430 431 1k
R431 431 432 1k
R432 432 433 1k
R433 433 434 1k
R434 434 435 1k
R435 435 436 1k
R436 436 437 1k
R437 437 438 1k
R438 438 439 1k
R439 439 440 1k
R440 440 441 1k
R441 441 442 1k
R442 442 443 1k
R443 443 444 1k
R444 444 445 1k
R445 445 446 1k
R446 446 447 1k
R447 447 448 1k
R448 448 449 1k
R449 449 450 1k
R450 450 451 1k
R451 451 452 1k
R452 452 453 1k
R453 453 454 1k
R454 454 455 1k
R455 455 456 1k
R456 456 457 1k
R457 457 458 1k
R458 458 459 1k
R459 459 460 1k
R460 460 461 1k
R461 461 462 1k
R462 462 463 1k
R463 463 464 1k
R464 464 465 1k
R465 465 466 1k
R466 466 467 1k
R467 467 468 1k
R468 468 469 1k
R469 469 470 1k
R470 470 471 1k
R471 471 472 1k
R472 472 473 1k
R473 473 474 1k
R474 474 475 1k
R475 475 476 1k
R476 476 477 1k
R477 477 478 1k
R478 478 479 1k
R479 479 480 1k
R480 480 481 1k
R481 481 482 1k
R482 482 483 1k
R483 483 484 1k
R484 484 485 1k
R485 485 486 1k
R486 486 487 1k
R487 487 488 1k
R488 488 489 1k
R489 489 490 1k
R490 490 491 1k
R491 491 492 1k
R492 492 493 1k
R493 493 494 1k
R494 494 495 1k
R495 495 496 1k
R496 496 497 1k
R497 497 498 1k
R498 498 499 1k
R499 499 500 1k
R500 500 501 1k
R501 501 502 1k
R502 502 503 1k
R503 503 504 1k
R504 504 505 1k
R505 505 506 1k
R506 506 507 1k
R507 507 508 1k
R508 508 509 1k
R509 509 510 1k
R510 510 511 1k
R511 511 512 1k
R512 512 513 1k
R513 513 514 1k
R514 514 515 1k
R515 515 516 1k
R516 516 517 1k
R517 517 518 1k
R518 518 519 1k
R519 519 520 1k
R520 520 521 1k
R521 521 522 1k
R522 522 523 1k
R523 523 524 1k
R524 524 525 1k
R525 525 526 1k
R526 526 527 1k
R527 527 528 1k
R528 528 529 1k
R529 529 530 1k
R530 530 531 1k
R531 531 532 1k
R532 532 533 1k
R533 533 534 1k
R534 534 535 1k
R535 535 536 1k
R536 536 537 1k
R537 537 538 1k
R538 538 539 1k
R539 539 540 1k
R540 540 541 1k
R541 541 542 1k
R542 542 543 1k
R543 543 544 1k
R544 544 545 1k
R545 545 546 1k
R546 546 547 1k
R547 547 548 1k
R548 548 549 1k
R549 549 550 1k
R550 550 551 1k
R551 551 552 1k
R552 552 553 1k
R553 553 554 1k
R554 554 555 1k
R555 555 556 1k
R556 556 557 1k
R557 557 558 1k
R558 558 559 1k
R559 559 560 1k
R560 560 561 1k
R561 561 562 1k
R562 562 563 1k
R563 563 564 1k
R564 564 565 1k
R565 565 566 1k
R566 566 567 1k
R567 567 568 1k
R568 568 569 1k
R569 569 570 1k
R570 570 571 1k
R571 571 572 1k
R572 572 573 1k
R573 573 574 1k
R574 574 575 1k
R575 575 576 1k
R576 576 577 1k
R577 577 578 1k
R578 578 579 1k
R579 579 580 1k
R580 580 581 1k
R581 581 582 1k
R582 582 583 1k
R583 583 584 1k
R584 584 585 1k
R585 585 586 1k
R586 586 587 1k
R587 587 588 1k
R588 588 589 1k
R589 589 590 1k
R590 590 591 1k
R591 591 592 1k
R592 592 593 1k
R593 593 594 1k
R594 594 595 1k
R595 595 596 1k
R596 596 597 1k
R597 597 598 1k
R598 598 599 1k
R599 599 600 1k
R600 600 601 1k
R601 601 602 1k
R602 602 603 1k
R603 603 604 1k
R604 604 605 1k
R605 605 606 1k
R606 606 607 1k
R607 607 608 1k
R608 608 609 1k
R609 609 610 1k
R610 610 611 1k
R611 611 612 1k
R612 612 613 1k
R613 613 614 1k
R614 614 615 1k
R615 615 616 1k
R616 616 617 1k
R617 617 618 1k
R618 618 619 1k
R619 619 620 1k
R620 620 621 1k
R621 621 622 1k
R622 622 623 1k
R623 623 624 1k
R624 624 625 1k
R625 625 626 1k
R626 626 627 1k
R627 627 628 1k
R628 628 629 1k
R629 629 630 1k
R630 630 631 1k
R631 631 632 1k
R632 632 633 1k
R633 633 634 1k
R634 634 635 1k
R635 635 636 1k
R636 636 637 1k
R637 637 638 1k
R638 638 639 1k
R639 639 640 1k
R640 640 641 1k
R641 641 642 1k
R642 642 643 1k
R643 643 644 1k
R644 644 645 1k
R645 645 646 1k
R646 646 647 1k
R647 647 648 1k
R648 648 649 1k
R649 649 650 1k
R650 650 651 1k
R651 651 652 1k
R652 652 653 1k
R653 653 654 1k
R654 654 655 1k
R655 655 656 1k
R656 656 657 1k
R657 657 658 1k
R658 658 659 1k
R659 659 660 1k
R660 660 661 1k
R661 661 662 1k
R662 662 663 1k
R663 663 664 1k
R664 664 665 1k
R665 665 666 1k
R666 666 667 1k
R667 667 668 1k
R668 668 669 1k
R669 669 670 1k
R670 670 671 1k
R671 671 672 1k
R672 672 673 1k
R673 673 674 1k
R674 674 675 1k
R675 675 676 1k
R676 676 677 1k
R677 677 678 1k
R678 678 679 1k
R679 679 680 1k
R680 680 681 1k
R681 681 682 1k
R682 682 683 1k
R683 683 684 1k
R684 684 685 1k
R685 685 686 1k
R686 686 687 1k
R687 687 688 1k
R688 688 689 1k
R689 689 690 1k
R690 690 691 1k
R691 691 692 1k
R692 692 693 1k
R693 693 694 1k
R694 694 695 1k
R695 695 696 1k
R696 696 697 1k
R697 697 698 1k
R698 698 699 1k
R699 699 700 1k
R700 700 701 1k
R701 701 702 1k
R702 702 703 1k
R703 703 704 1k
R704 704 705 1k
R705 705 706 1k
R706 706 707 1k
R707 707 708 1k
R708 708 709 1k
R709 709 710 1k
R710 710 711 1k
R711 711 712 1k
R712 712 713 1k
R713 713 714 1k
R714 714 715 1k
R715 715 716 1k
R716 716 717 1k
R717 717 718 1k
R718 718 719 1k
R719 719 720 1k
R720 720 721 1k
R721 721 722 1k
R722 722 723 1k
R723 723 724 1k
R724 724 725 1k
R725 725 726 1k
R726 726 727 1k
R727 727 728 1k
R728 728 729 1k
R729 729 730 1k
R730 730 731 1k
R731 731 732 1k
R732 732 733 1k
R733 733 734 1k
R734 734 735 1k
R735 735 736 1k
R736 736 737 1k
R737 737 738 1k
R738 738 739 1k
R739 739 740 1k
R740 740 741 1k
R741 741 742 1k
R742 742 743 1k
R743 743 744 1k
R744 744 745 1k
R745 745 746 1k
R746 746 747 1k
R747 747 748 1k
R748 748 749 1k
R749 749 750 1k
R750 750 751 1k
R751 751 752 1k
R752 752 753 1k
R753 753 754 1k
R754 754 755 1k
R755 755 756 1k
R756 756 757 1k
R757 757 758 1k
R758 758 759 1k
R759 759 760 1k
R760 760 761 1k
R761 761 762 1k
R762 762 763 1k
R763 763 764 1k
R764 764 765 1k
R765 765 766 1k
R766 766 767 1k
R767 767 768 1k
R768 768 769 1k
R769 769 770 1k
R770 770 771 1k
R771 771 772 1k
R772 772 773 1k
R773 773 774 1k
R774 774 775 1k
R775 775 776 1k
R776 776 777 1k
R777 777 778 1k
R778 778 779 1k
R779 779 780 1k
R780 780 781 1k
R781 781 782 1k
R782 782 783 1k
R783 783 784 1k
R784 784 785 1k
R785 785 786 1k
R786 786 787 1k
R787 787 788 1k
R788 788 789 1k
R789 789 790 1k
R790 790 791 1k
R791 791 792 1k
R792 792 793 1k
R793 793 794 1k
R794 794 795 1k
R795 795 796 1k
R796 796 797 1k
R797 797 798 1k
R798 798 799 1k
R799 799 800 1k
R800 800 801 1k
R801 801 802 1k
R802 802 803 1k
R803 803 804 1k
R804 804 805 1k
R805 805 806 1k
R806 806 807 1k
R807 807 808 1k
R808 808 809 1k
R809 809 810 1k
R810 810 811 1k
R811 811 812 1k
R812 812 813 1k
R813 813 814 1k
R814 814 815 1k
R815 815 816 1k
R816 816 817 1k
R817 817 818 1k
R818 818 819 1k
R819 819 820 1k
R820 820 821 1k
R821 821 822 1k
R822 822 823 1k
R823 823 824 1k
R824 824 825 1k
R825 825 826 1k
R826 826 827 1k
R827 827 828 1k
R828 828 829 1k
R829 829 830 1k
R830 830 831 1k
R831 831 832 1k
R832 832 833 1k
R833 833 834 1k
R834 834 835 1k
R835 835 836 1k
R836 836 837 1k
R837 837 838 1k
R838 838 839 1k
R839 839 840 1k
R840 840 841 1k
R841 841 842 1k
R842 842 843 1k
R843 843 844 1k
R844 844 845 1k
R845 845 846 1k
R846 846 847 1k
R847 847 848 1k
R848 848 849 1k
R849 849 850 1k
R850 850 851 1k
R851 851 852 1k
R852 852 853 1k
R853 853 854 1k
R854 854 855 1k
R855 855 856 1k
R856 856 857 1k
R857 857 858 1k
R858 858 859 1k
R859 859 860 1k
R860 860 861 1k
R861 861 862 1k
R862 862 863 1k
R863 863 864 1k
R864 864 865 1k
R865 865 866 1k
R866 866 867 1k
R867 867 868 1k
R868 868 869 1k
R869 869 870 1k
R870 870 871 1k
R871 871 872 1k
R872 872 873 1k
R873 873 874 1k
R874 874 875 1k
R875 875 876 1k
R876 876 877 1k
R877 877 878 1k
R878 878 879 1k
R879 879 880 1k
R880 880 881 1k
R881 881 882 1k
R882 882 883 1k
R883 883 884 1k
R884 884 885 1k
R885 885 886 1k
R886 886 887 1k
R887 887 888 1k
R888 888 889 1k
R889 889 890 1k
R890 890 891 1k
R891 891 892 1k
R892 892 893 1k
R893 893 894 1k
R894 894 895 1k
R895 895 896 1k
R896 896 897 1k
R897 897 898 1k
R898 898 899 1k
R899 899 900 1k
R900 900 901 1k
R901 901 902 1k
R902 902 903 1k
R903 903 904 1k
R904 904 905 1k
R905 905 906 1k
R906 906 907 1k
R907 907 908 1k
R908 908 909 1k
R909 909 910 1k
R910 910 911 1k
R911 911 912 1k
R912 912 913 1k
R913 913 914 1k
R914 914 915 1k
R915 915 916 1k
R916 916 917 1k
R917 917 918 1k
R918 918 919 1k
R919 919 920 1k
R920 920 921 1k
R921 921 922 1k
R922 922 923 1k
R923 923 924 1k
R924 924 925 1k
R925 925 926 1k
R926 926 927 1k
R927 927 928 1k
R928 928 929 1k
R929 929 930 1k
R930 930 931 1k
R931 931 932 1k
R932 932 933 1k
R933 933 934 1k
R934 934 935 1k
R935 935 936 1k
R936 936 937 1k
R937 937 938 1k
R938 938 939 1k
R939 939 940 1k
R940 940 941 1k
R941 941 942 1k
R942 942 943 1k
R943 943 944 1k
R944 944 945 1k
R945 945 946 1k
R946 946 947 1k
R947 947 948 1k
R948 948 949 1k
R949 949 950 1k
R950 950 951 1k
R951 951 952 1k
R952 952 953 1k
R953 953 954 1k
R954 954 955 1k
R955 955 956 1k
R956 956 957 1k
R957 957 958 1k
R958 958 959 1k
R959 959 960 1k
R960 960 961 1k
R961 961 962 1k
R962 962 963 1k
R963 963 964 1k
R964 964 965 1k
R965 965 966 1k
R966 966 967 1k
R967 967 968 1k
R968 968 969 1k
R969 969 970 1k
R970 970 971 1k
R971 971 972 1k
R972 972 973 1k
R973 973 974 1k
R974 974 975 1k
R975 975 976 1k
R976 976 977 1k
R977 977 978 1k
R978 978 979 1k
R979 979 980 1k
R980 980 981 1k
R981 981 982 1k
R982 982 983 1k
R983 983 984 1k
R984 984 985 1k
R985 985 986 1k
R986 986 987 1k
R987 987 988 1k
R988 988 989 1k
R989 989 990 1k
R990 990 991 1k
R991 991 992 1k
R992 992 993 1k
R993 993 994 1k
R994 994 995 1k
R995 995 996 1k
R996 996 997 1k
R997 997 998 1k
R998 998 999 1k
R999 999 1000 1k
R1000 1000 1001 1k
C1 2 0 1p
C2 3 0 1p
C3 4 0 1p
C4 5 0 1p
C5 6 0 1p
C6 7 0 1p
C7 8 0 1p
C8 9 0 1p
C9 10 0 1p
C10 11 0 1p
C11 12 0 1p
C12 13 0 1p
C13 14 0 1p
C14 15 0 1p
C15 16 0 1p
C16 17 0 1p
C17 18 0 1p
C18 19 0 1p
C19 20 0 1p
C20 21 0 1p
C21 22 0 1p
C22 23 0 1p
C23 24 0 1p
C24 25 0 1p
C25 26 0 1p
C26 27 0 1p
C27 28 0 1p
C28 29 0 1p
C29 30 0 1p
C30 31 0 1p
C31 32 0 1p
C32 33 0 1p
C33 34 0 1p
C34 35 0 1p
C35 36 0 1p
C36 37 0 1p
C37 38 0 1p
C38 39 0 1p
C39 40 0 1p
C40 41 0 1p
C41 42 0 1p
C42 43 0 1p
C43 44 0 1p
C44 45 0 1p
C45 46 0 1p
C46 47 0 1p
C47 48 0 1p
C48 49 0 1p
C49 50 0 1p
C50 51 0 1p
C51 52 0 1p
C52 53 0 1p
C53 54 0 1p
C54 55 0 1p
C55 56 0 1p
C56 57 0 1p
C57 58 0 1p
C58 59 0 1p
C59 60 0 1p
C60 61 0 1p
C61 62 0 1p
C62 63 0 1p
C63 64 0 1p
C64 65 0 1p
C65 66 0 1p
C66 67 0 1p
C67 68 0 1p
C68 69 0 1p
C69 70 0 1p
C70 71 0 1p
C71 72 0 1p
C72 73 0 1p
C73 74 0 1p
C74 75 0 1p
C75 76 0 1p
C76 77 0 1p
C77 78 0 1p
C78 79 0 1p
C79 80 0 1p
C80 81 0 1p
C81 82 0 1p
C82 83 0 1p
C83 84 0 1p
C84 85 0 1p
C85 86 0 1p
C86 87 0 1p
C87 88 0 1p
C88 89 0 1p
C89 90 0 1p
C90 91 0 1p
C91 92 0 1p
C92 93 0 1p
C93 94 0 1p
C94 95 0 1p
C95 96 0 1p
C96 97 0 1p
C97 98 0 1p
C98 99 0 1p
C99 100 0 1p
C100 101 0 1p
C101 102 0 1p
C102 103 0 1p
C103 104 0 1p
C104 105 0 1p
C105 106 0 1p
C106 107 0 1p
C107 108 0 1p
C108 109 0 1p
C109 110 0 1p
C110 111 0 1p
C111 112 0 1p
C112 113 0 1p
C113 114 0 1p
C114 115 0 1p
C115 116 0 1p
C116 117 0 1p
C117 118 0 1p
C118 119 0 1p
C119 120 0 1p
C120 121 0 1p
C121 122 0 1p
C122 123 0 1p
C123 124 0 1p
C124 125 0 1p
C125 126 0 1p
C126 127 0 1p
C127 128 0 1p
C128 129 0 1p
C129 130 0 1p
C130 131 0 1p
C131 132 0 1p
C132 133 0 1p
C133 134 0 1p
C134 135 0 1p
C135 136 0 1p
C136 137 0 1p
C137 138 0 1p
C138 139 0 1p
C139 140 0 1p
C140 141 0 1p
C141 142 0 1p
C142 143 0 1p
C143 144 0 1p
C144 145 0 1p
C145 146 0 1p
C146 147 0 1p
C147 148 0 1p
C148 149 0 1p
C149 150 0 1p
C150 151 0 1p
C151 152 0 1p
C152 153 0 1p
C153 154 0 1p
C154 155 0 1p
C155 156 0 1p
C156 157 0 1p
C157 158 0 1p
C158 159 0 1p
C159 160 0 1p
C160 161 0 1p
C161 162 0 1p
C162 163 0 1p
C163 164 0 1p
C164 165 0 1p
C165 166 0 1p
C166 167 0 1p
C167 168 0 1p
C168 169 0 1p
C169 170 0 1p
C170 171 0 1p
C171 172 0 1p
C172 173 0 1p
C173 174 0 1p
C174 175 0 1p
C175 176 0 1p
C176 177 0 1p
C177 178 0 1p
C178 179 0 1p
C179 180 0 1p
C180 181 0 1p
C181 182 0 1p
C182 183 0 1p
C183 184 0 1p
C184 185 0 1p
C185 186 0 1p
C186 187 0 1p
C187 188 0 1p
C188 189 0 1p
C189 190 0 1p
C190 191 0 1p
C191 192 0 1p
C192 193 0 1p
C193 194 0 1p
C194 195 0 1p
C195 196 0 1p
C196 197 0 1p
C197 198 0 1p
C198 199 0 1p
C199 200 0 1p
C200 201 0 1p
C201 202 0 1p
C202 203 0 1p
C203 204 0 1p
C204 205 0 1p
C205 206 0 1p
C206 207 0 1p
C207 208 0 1p
C208 209 0 1p
C209 210 0 1p
C210 211 0 1p
C211 212 0 1p
C212 213 0 1p
C213 214 0 1p
C214 215 0 1p
C215 216 0 1p
C216 217 0 1p
C217 218 0 1p
C218 219 0 1p
C219 220 0 1p
C220 221 0 1p
C221 222 0 1p
C222 223 0 1p
C223 224 0 1p
C224 225 0 1p
C225 226 0 1p
C226 227 0 1p
C227 228 0 1p
C228 229 0 1p
C229 230 0 1p
C230 231 0 1p
C231 232 0 1p
C232 233 0 1p
C233 234 0 1p
C234 235 0 1p
C235 236 0 1p
C236 237 0 1p
C237 238 0 1p
C238 239 0 1p
C239 240 0 1p
C240 241 0 1p
C241 242 0 1p
C242 243 0 1p
C243 244 0 1p
C244 245 0 1p
C245 246 0 1p
C246 247 0 1p
C247 248 0 1p
C248 249 0 1p
C249 250 0 1p
C250 251 0 1p
C251 252 0 1p
C252 253 0 1p
C253 254 0 1p
C254 255 0 1p
C255 256 0 1p
C256 257 0 1p
C257 258 0 1p
C258 259 0 1p
C259 260 0 1p
C260 261 0 1p
C261 262 0 1p
C262 263 0 1p
C263 264 0 1p
C264 265 0 1p
C265 266 0 1p
C266 267 0 1p
C267 268 0 1p
C268 269 0 1p
C269 270 0 1p
C270 271 0 1p
C271 272 0 1p
C272 273 0 1p
C273 274 0 1p
C274 275 0 1p
C275 276 0 1p
C276 277 0 1p
C277 278 0 1p
C278 279 0 1p
C279 280 0 1p
C280 281 0 1p
C281 282 0 1p
C282 283 0 1p
C283 284 0 1p
C284 285 0 1p
C285 286 0 1p
C286 287 0 1p
C287 288 0 1p
C288 289 0 1p
C289 290 0 1p
C290 291 0 1p
C291 292 0 1p
C292 293 0 1p
C293 294 0 1p
C294 295 0 1p
C295 296 0 1p
C296 297 0 1p
C297 298 0 1p
C298 299 0 1p
C299 300 0 1p
C300 301 0 1p
C301 302 0 1p
C302 303 0 1p
C303 304 0 1p
C304 305 0 1p
C305 306 0 1p
C306 307 0 1p
C307 308 0 1p
C308 309 0 1p
C309 310 0 1p
C310 311 0 1p
C311 312 0 1p
C312 313 0 1p
C313 314 0 1p
C314 315 0 1p
C315 316 0 1p
C316 317 0 1p
C317 318 0 1p
C318 319 0 1p
C319 320 0 1p
C320 321 0 1p
C321 322 0 1p
C322 323 0 1p
C323 324 0 1p
C324 325 0 1p
C325 326 0 1p
C326 327 0 1p
C327 328 0 1p
C328 329 0 1p
C329 330 0 1p
C330 331 0 1p
C331 332 0 1p
C332 333 0 1p
C333 334 0 1p
C334 335 0 1p
C335 336 0 1p
C336 337 0 1p
C337 338 0 1p
C338 339 0 1p
C339 340 0 1p
C340 341 0 1p
C341 342 0 1p
C342 343 0 1p
C343 344 0 1p
C344 345 0 1p
C345 346 0 1p
C346 347 0 1p
C347 348 0 1p
C348 349 0 1p
C349 350 0 1p
C350 351 0 1p
C351 352 0 1p
C352 353 0 1p
C353 354 0 1p
C354 355 0 1p
C355 356 0 1p
C356 357 0 1p
C357 358 0 1p
C358 359 0 1p
C359 360 0 1p
C360 361 0 1p
C361 362 0 1p
C362 363 0 1p
C363 364 0 1p
C364 365 0 1p
C365 366 0 1p
C366 367 0 1p
C367 368 0 1p
C368 369 0 1p
C369 370 0 1p
C370 371 0 1p
C371 372 0 1p
C372 373 0 1p
C373 374 0 1p
C374 375 0 1p
C375 376 0 1p
C376 377 0 1p
C377 378 0 1p
C378 379 0 1p
C379 380 0 1p
C380 381 0 1p
C381 382 0 1p
C382 383 0 1p
C383 384 0 1p
C384 385 0 1p
C385 386 0 1p
C386 387 0 1p
C387 388 0 1p
C388 389 0 1p
C389 390 0 1p
C390 391 0 1p
C391 392 0 1p
C392 393 0 1p
C393 394 0 1p
C394 395 0 1p
C395 396 0 1p
C396 397 0 1p
C397 398 0 1p
C398 399 0 1p
C399 400 0 1p
C400 401 0 1p
C401 402 0 1p
C402 403 0 1p
C403 404 0 1p
C404 405 0 1p
C405 406 0 1p
C406 407 0 1p
C407 408 0 1p
C408 409 0 1p
C409 410 0 1p
C410 411 0 1p
C411 412 0 1p
C412 413 0 1p
C413 414 0 1p
C414 415 0 1p
C415 416 0 1p
C416 417 0 1p
C417 418 0 1p
C418 419 0 1p
C419 420 0 1p
C420 421 0 1p
C421 422 0 1p
C422 423 0 1p
C423 424 0 1p
C424 425 0 1p
C425 426 0 1p
C426 427 0 1p
C427 428 0 1p
C428 429 0 1p
C429 430 0 1p
C430 431 0 1p
C431 432 0 1p
C432 433 0 1p
C433 434 0 1p
C434 435 0 1p
C435 436 0 1p
C436 437 0 1p
C437 438 0 1p
C438 439 0 1p
C439 440 0 1p
C440 441 0 1p
C441 442 0 1p
C442 443 0 1p
C443 444 0 1p
C444 445 0 1p
C445 446 0 1p
C446 447 0 1p
C447 448 0 1p
C448 449 0 1p
C449 450 0 1p
C450 451 0 1p
C451 452 0 1p
C452 453 0 1p
C453 454 0 1p
C454 455 0 1p
C455 456 0 1p
C456 457 0 1p
C457 458 0 1p
C458 459 0 1p
C459 460 0 1p
C460 461 0 1p
C461 462 0 1p
C462 463 0 1p
C463 464 0 1p
C464 465 0 1p
C465 466 0 1p
C466 467 0 1p
C467 468 0 1p
C468 469 0 1p
C469 470 0 1p
C470 471 0 1p
C471 472 0 1p
C472 473 0 1p
C473 474 0 1p
C474 475 0 1p
C475 476 0 1p
C476 477 0 1p
C477 478 0 1p
C478 479 0 1p
C479 480 0 1p
C480 481 0 1p
C481 482 0 1p
C482 483 0 1p
C483 484 0 1p
C484 485 0 1p
C485 486 0 1p
C486 487 0 1p
C487 488 0 1p
C488 489 0 1p
C489 490 0 1p
C490 491 0 1p
C491 492 0 1p
C492 493 0 1p
C493 494 0 1p
C494 495 0 1p
C495 496 0 1p
C496 497 0 1p
C497 498 0 1p
C498 499 0 1p
C499 500 0 1p
C500 501 0 1p
C501 502 0 1p
C502 503 0 1p
C503 504 0 1p
C504 505 0 1p
C505 506 0 1p
C506 507 0 1p
C507 508 0 1p
C508 509 0 1p
C509 510 0 1p
C510 511 0 1p
C511 512 0 1p
C512 513 0 1p
C513 514 0 1p
C514 515 0 1p
C515 516 0 1p
C516 517 0 1p
C517 518 0 1p
C518 519 0 1p
C519 520 0 1p
C520 521 0 1p
C521 522 0 1p
C522 523 0 1p
C523 524 0 1p
C524 525 0 1p
C525 526 0 1p
C526 527 0 1p
C527 528 0 1p
C528 529 0 1p
C529 530 0 1p
C530 531 0 1p
C531 532 0 1p
C532 533 0 1p
C533 534 0 1p
C534 535 0 1p
C535 536 0 1p
C536 537 0 1p
C537 538 0 1p
C538 539 0 1p
C539 540 0 1p
C540 541 0 1p
C541 542 0 1p
C542 543 0 1p
C543 544 0 1p
C544 545 0 1p
C545 546 0 1p
C546 547 0 1p
C547 548 0 1p
C548 549 0 1p
C549 550 0 1p
C550 551 0 1p
C551 552 0 1p
C552 553 0 1p
C553 554 0 1p
C554 555 0 1p
C555 556 0 1p
C556 557 0 1p
C557 558 0 1p
C558 559 0 1p
C559 560 0 1p
C560 561 0 1p
C561 562 0 1p
C562 563 0 1p
C563 564 0 1p
C564 565 0 1p
C565 566 0 1p
C566 567 0 1p
C567 568 0 1p
C568 569 0 1p
C569 570 0 1p
C570 571 0 1p
C571 572 0 1p
C572 573 0 1p
C573 574 0 1p
C574 575 0 1p
C575 576 0 1p
C576 577 0 1p
C577 578 0 1p
C578 579 0 1p
C579 580 0 1p
C580 581 0 1p
C581 582 0 1p
C582 583 0 1p
C583 584 0 1p
C584 585 0 1p
C585 586 0 1p
C586 587 0 1p
C587 588 0 1p
C588 589 0 1p
C589 590 0 1p
C590 591 0 1p
C591 592 0 1p
C592 593 0 1p
C593 594 0 1p
C594 595 0 1p
C595 596 0 1p
C596 597 0 1p
C597 598 0 1p
C598 599 0 1p
C599 600 0 1p
C600 601 0 1p
C601 602 0 1p
C602 603 0 1p
C603 604 0 1p
C604 605 0 1p
C605 606 0 1p
C606 607 0 1p
C607 608 0 1p
C608 609 0 1p
C609 610 0 1p
C610 611 0 1p
C611 612 0 1p
C612 613 0 1p
C613 614 0 1p
C614 615 0 1p
C615 616 0 1p
C616 617 0 1p
C617 618 0 1p
C618 619 0 1p
C619 620 0 1p
C620 621 0 1p
C621 622 0 1p
C622 623 0 1p
C623 624 0 1p
C624 625 0 1p
C625 626 0 1p
C626 627 0 1p
C627 628 0 1p
C628 629 0 1p
C629 630 0 1p
C630 631 0 1p
C631 632 0 1p
C632 633 0 1p
C633 634 0 1p
C634 635 0 1p
C635 636 0 1p
C636 637 0 1p
C637 638 0 1p
C638 639 0 1p
C639 640 0 1p
C640 641 0 1p
C641 642 0 1p
C642 643 0 1p
C643 644 0 1p
C644 645 0 1p
C645 646 0 1p
C646 647 0 1p
C647 648 0 1p
C648 649 0 1p
C649 650 0 1p
C650 651 0 1p
C651 652 0 1p
C652 653 0 1p
C653 654 0 1p
C654 655 0 1p
C655 656 0 1p
C656 657 0 1p
C657 658 0 1p
C658 659 0 1p
C659 660 0 1p
C660 661 0 1p
C661 662 0 1p
C662 663 0 1p
C663 664 0 1p
C664 665 0 1p
C665 666 0 1p
C666 667 0 1p
C667 668 0 1p
C668 669 0 1p
C669 670 0 1p
C670 671 0 1p
C671 672 0 1p
C672 673 0 1p
C673 674 0 1p
C674 675 0 1p
C675 676 0 1p
C676 677 0 1p
C677 678 0 1p
C678 679 0 1p
C679 680 0 1p
C680 681 0 1p
C681 682 0 1p
C682 683 0 1p
C683 684 0 1p
C684 685 0 1p
C685 686 0 1p
C686 687 0 1p
C687 688 0 1p
C688 689 0 1p
C689 690 0 1p
C690 691 0 1p
C691 692 0 1p
C692 693 0 1p
C693 694 0 1p
C694 695 0 1p
C695 696 0 1p
C696 697 0 1p
C697 698 0 1p
C698 699 0 1p
C699 700 0 1p
C700 701 0 1p
C701 702 0 1p
C702 703 0 1p
C703 704 0 1p
C704 705 0 1p
C705 706 0 1p
C706 707 0 1p
C707 708 0 1p
C708 709 0 1p
C709 710 0 1p
C710 711 0 1p
C711 712 0 1p
C712 713 0 1p
C713 714 0 1p
C714 715 0 1p
C715 716 0 1p
C716 717 0 1p
C717 718 0 1p
C718 719 0 1p
C719 720 0 1p
C720 721 0 1p
C721 722 0 1p
C722 723 0 1p
C723 724 0 1p
C724 725 0 1p
C725 726 0 1p
C726 727 0 1p
C727 728 0 1p
C728 729 0 1p
C729 730 0 1p
C730 731 0 1p
C731 732 0 1p
C732 733 0 1p
C733 734 0 1p
C734 735 0 1p
C735 736 0 1p
C736 737 0 1p
C737 738 0 1p
C738 739 0 1p
C739 740 0 1p
C740 741 0 1p
C741 742 0 1p
C742 743 0 1p
C743 744 0 1p
C744 745 0 1p
C745 746 0 1p
C746 747 0 1p
C747 748 0 1p
C748 749 0 1p
C749 750 0 1p
C750 751 0 1p
C751 752 0 1p
C752 753 0 1p
C753 754 0 1p
C754 755 0 1p
C755 756 0 1p
C756 757 0 1p
C757 758 0 1p
C758 759 0 1p
C759 760 0 1p
C760 761 0 1p
C761 762 0 1p
C762 763 0 1p
C763 764 0 1p
C764 765 0 1p
C765 766 0 1p
C766 767 0 1p
C767 768 0 1p
C768 769 0 1p
C769 770 0 1p
C770 771 0 1p
C771 772 0 1p
C772 773 0 1p
C773 774 0 1p
C774 775 0 1p
C775 776 0 1p
C776 777 0 1p
C777 778 0 1p
C778 779 0 1p
C779 780 0 1p
C780 781 0 1p
C781 782 0 1p
C782 783 0 1p
C783 784 0 1p
C784 785 0 1p
C785 786 0 1p
C786 787 0 1p
C787 788 0 1p
C788 789 0 1p
C789 790 0 1p
C790 791 0 1p
C791 792 0 1p
C792 793 0 1p
C793 794 0 1p
C794 795 0 1p
C795 796 0 1p
C796 797 0 1p
C797 798 0 1p
C798 799 0 1p
C799 800 0 1p
C800 801 0 1p
C801 802 0 1p
C802 803 0 1p
C803 804 0 1p
C804 805 0 1p
C805 806 0 1p
C806 807 0 1p
C807 808 0 1p
C808 809 0 1p
C809 810 0 1p
C810 811 0 1p
C811 812 0 1p
C812 813 0 1p
C813 814 0 1p
C814 815 0 1p
C815 816 0 1p
C816 817 0 1p
C817 818 0 1p
C818 819 0 1p
C819 820 0 1p
C820 821 0 1p
C821 822 0 1p
C822 823 0 1p
C823 824 0 1p
C824 825 0 1p
C825 826 0 1p
C826 827 0 1p
C827 828 0 1p
C828 829 0 1p
C829 830 0 1p
C830 831 0 1p
C831 832 0 1p
C832 833 0 1p
C833 834 0 1p
C834 835 0 1p
C835 836 0 1p
C836 837 0 1p
C837 838 0 1p
C838 839 0 1p
C839 840 0 1p
C840 841 0 1p
C841 842 0 1p
C842 843 0 1p
C843 844 0 1p
C844 845 0 1p
C845 846 0 1p
C846 847 0 1p
C847 848 0 1p
C848 849 0 1p
C849 850 0 1p
C850 851 0 1p
C851 852 0 1p
C852 853 0 1p
C853 854 0 1p
C854 855 0 1p
C855 856 0 1p
C856 857 0 1p
C857 858 0 1p
C858 859 0 1p
C859 860 0 1p
C860 861 0 1p
C861 862 0 1p
C862 863 0 1p
C863 864 0 1p
C864 865 0 1p
C865 866 0 1p
C866 867 0 1p
C867 868 0 1p
C868 869 0 1p
C869 870 0 1p
C870 871 0 1p
C871 872 0 1p
C872 873 0 1p
C873 874 0 1p
C874 875 0 1p
C875 876 0 1p
C876 877 0 1p
C877 878 0 1p
C878 879 0 1p
C879 880 0 1p
C880 881 0 1p
C881 882 0 1p
C882 883 0 1p
C883 884 0 1p
C884 885 0 1p
C885 886 0 1p
C886 887 0 1p
C887 888 0 1p
C888 889 0 1p
C889 890 0 1p
C890 891 0 1p
C891 892 0 1p
C892 893 0 1p
C893 894 0 1p
C894 895 0 1p
C895 896 0 1p
C896 897 0 1p
C897 898 0 1p
C898 899 0 1p
C899 900 0 1p
C900 901 0 1p
C901 902 0 1p
C902 903 0 1p
C903 904 0 1p
C904 905 0 1p
C905 906 0 1p
C906 907 0 1p
C907 908 0 1p
C908 909 0 1p
C909 910 0 1p
C910 911 0 1p
C911 912 0 1p
C912 913 0 1p
C913 914 0 1p
C914 915 0 1p
C915 916 0 1p
C916 917 0 1p
C917 918 0 1p
C918 919 0 1p
C919 920 0 1p
C920 921 0 1p
C921 922 0 1p
C922 923 0 1p
C923 924 0 1p
C924 925 0 1p
C925 926 0 1p
C926 927 0 1p
C927 928 0 1p
C928 929 0 1p
C929 930 0 1p
C930 931 0 1p
C931 932 0 1p
C932 933 0 1p
C933 934 0 1p
C934 935 0 1p
C935 936 0 1p
C936 937 0 1p
C937 938 0 1p
C938 939 0 1p
C939 940 0 1p
C940 941 0 1p
C941 942 0 1p
C942 943 0 1p
C943 944 0 1p
C944 945 0 1p
C945 946 0 1p
C946 947 0 1p
C947 948 0 1p
C948 949 0 1p
C949 950 0 1p
C950 951 0 1p
C951 952 0 1p
C952 953 0 1p
C953 954 0 1p
C954 955 0 1p
C955 956 0 1p
C956 957 0 1p
C957 958 0 1p
C958 959 0 1p
C959 960 0 1p
C960 961 0 1p
C961 962 0 1p
C962 963 0 1p
C963 964 0 1p
C964 965 0 1p
C965 966 0 1p
C966 967 0 1p
C967 968 0 1p
C968 969 0 1p
C969 970 0 1p
C970 971 0 1p
C971 972 0 1p
C972 973 0 1p
C973 974 0 1p
C974 975 0 1p
C975 976 0 1p
C976 977 0 1p
C977 978 0 1p
C978 979 0 1p
C979 980 0 1p
C980 981 0 1p
C981 982 0 1p
C982 983 0 1p
C983 984 0 1p
C984 985 0 1p
C985 986 0 1p
C986 987 0 1p
C987 988 0 1p
C988 989 0 1p
C989 990 0 1p
C990 991 0 1p
C991 992 0 1p
C992 993 0 1p
C993 994 0 1p
C994 995 0 1p
C995 996 0 1p
C996 997 0 1p
C997 998 0 1p
C998 999 0 1p
C999 1000 0 1p
C1000 1001 0 1p
.TRAN 0.1n 10u
.END
