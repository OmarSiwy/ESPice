* Mismatch of an ideal-clamped node
* Expected results: zero_source.expected.json
Vin out 0 0
R1 out 0 1000
.dcmatch v(out)
.end
