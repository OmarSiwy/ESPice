* Mismatch of an ideal-clamped node
* Expected results: high_resistance.expected.json
Vin out 0 2
R1 out 0 1000000.0
.dcmatch v(out)
.end
