* Adjoint mismatch combines independent sensitivities in quadrature
* Expected results: divider_0_1000.expected.json
Vin in 0 0
R1 in out 1000
R2 out 0 3000
.dcmatch v(out)
.end
