* Mismatch of an ideal-clamped node
* Expected results: unit_source.expected.json
Vin out 0 1
R1 out 0 1000
.dcmatch v(out)
.end
