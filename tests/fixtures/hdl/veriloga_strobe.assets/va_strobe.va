// Verilog-A linear resistor, 100 ohm default, that reports its drop with
// $strobe at every accepted point (LRM 9.4.6).
`include "disciplines.vams"
module va_strobe(p, n);
    inout p, n;
    electrical p, n;

    parameter real R = 100.0 from (0:inf);

    analog begin
        I(p, n) <+ V(p, n) / R;
        $strobe("%m vdrop = %g", V(p, n));
    end
endmodule
