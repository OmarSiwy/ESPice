* A table capture is kept only from an accepted iteration: the converged op reads the data captured at its solution.
.hdl "veriloga_table_snapshot.assets/va_table_snapshot.va"
N1 out 0 va_table_snapshot
.op
.end
