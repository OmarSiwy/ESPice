* First-call table values remain fixed while Newton changes V(out).
.hdl "veriloga_table_snapshot.assets/va_table_snapshot.va"
N1 out 0 va_table_snapshot
.op
.end
