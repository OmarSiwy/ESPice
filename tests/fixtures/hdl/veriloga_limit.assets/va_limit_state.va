`include "disciplines.vams"
// Exercises iteration history together with accepted reactive history.
module va_limit_state(p, n);
    inout p, n;
    electrical p, n;
    analog function real halfvolt;
        input value, previous;
        real value, previous, limited;
        begin
            if ($simparam("iteration") == 1)
                limited = 0.0;
            else
                limited = min(max(value, previous - 0.5), previous + 0.5);
            if (abs(limited - value) > 1e-12) $discontinuity(-1);
            halfvolt = limited;
        end
    endfunction
    analog begin
        I(p,n) <+ exp($limit(V(p,n), halfvolt)) - exp(2.0 + $abstime);
        I(p,n) <+ (1.0 + V(p,n)) * ddt(V(p,n));
    end
endmodule
