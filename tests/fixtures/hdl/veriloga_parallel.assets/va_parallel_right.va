`include "disciplines.vams"
module va_parallel_right(p,n);
    inout p,n;
    electrical p,n;
    analog I(p,n) <+ V(p,n)/2000.0;
endmodule
