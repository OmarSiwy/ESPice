* Temperature-invariant ideal divider
* Expected results: fine.expected.json
Vin in 0 10
R1 in out 1000
R2 out 0 3000
.temp 20 30 1
.end
