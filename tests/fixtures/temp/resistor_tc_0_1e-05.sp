* Linear and quadratic resistor temperature coefficients
* Expected results: resistor_tc_0_1e-05.expected.json
Vin in 0 10
R1 in out 1k
R2 out 0 3k tc1=0 tc2=1e-05
.temp -40 120 40
.end
