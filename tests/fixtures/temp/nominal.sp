* Temperature-invariant ideal divider
* Expected results: nominal.expected.json
Vin in 0 10
R1 in out 1000
R2 out 0 3000
.temp 27 27 1
.end
