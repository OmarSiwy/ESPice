* Temperature-invariant ideal divider
* Expected results: wide.expected.json
Vin in 0 10
R1 in out 1000
R2 out 0 3000
.temp -40 125 55
.end
