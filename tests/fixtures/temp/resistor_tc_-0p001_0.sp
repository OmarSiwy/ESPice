* Linear and quadratic resistor temperature coefficients
* Expected results: resistor_tc_-0p001_0.expected.json
Vin in 0 10
R1 in out 1k
R2 out 0 3k tc1=-0.001 tc2=0
.temp -40 120 40
.end
