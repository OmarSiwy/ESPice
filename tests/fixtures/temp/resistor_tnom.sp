* .options tnom reaches R tc1/tc2 (#146)
* Expected results: resistor_tnom.expected.json
V1 a 0 1
R1 a 0 1k tc1=0.01
.options tnom=0
.op
.end
