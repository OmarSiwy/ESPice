* Carrier-window absolute peak and RMS
* Expected results: negative_offset.expected.json
Vin out 0 SIN(-3 2 1k)
R1 out 0 1k
.envelope 1m 5m
.end
