* Carrier-window absolute peak and RMS
* Expected results: zero.expected.json
Vin out 0 SIN(0 0 1k)
R1 out 0 1k
.envelope 1m 5m
.end
