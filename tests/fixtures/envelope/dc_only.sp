* Carrier-window absolute peak and RMS
* Expected results: dc_only.expected.json
Vin out 0 SIN(2 0 1k)
R1 out 0 1k
.envelope 1m 5m
.end
