* Envelope must account for RC startup history and carrier filtering
* Expected results: rc_startup_1e-05.expected.json
Vin in 0 SIN(0 1 1k)
R1 in out 1k
C1 out 0 1e-08
.envelope 1m 5m
.end
