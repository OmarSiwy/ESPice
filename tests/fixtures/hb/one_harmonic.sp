* Harmonic balance with physical voltage drive
* Expected results: one_harmonic.expected.json
Vin in 0 SIN(0 1 1k)
R1 in out 1000
C1 out 0 1e-06
.hb 1k 1
.end
