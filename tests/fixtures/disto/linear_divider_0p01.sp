* Linear circuits have exactly zero second-order distortion
* Expected results: linear_divider_0p01.expected.json
Vin in 0 DC 1 DISTOF1 0.01
R1 in out 1000
R2 out 0 3000
.disto dec 3 100 10k
.end
