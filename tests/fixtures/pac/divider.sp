* LTI PAC must reduce to the AC voltage-source transfer
* Expected results: divider.expected.json
Vin in 0 DC 0 AC 1 SIN(0 1 1k)
R1 in out 1000
R2 out 0 3000
.pac 1k dec 4 10 10k
.end
