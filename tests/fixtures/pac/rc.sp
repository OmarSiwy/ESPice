* LTI PAC must reduce to the AC voltage-source transfer
* Expected results: rc.expected.json
Vin in 0 AC 1 SIN(0 1 1k)
R1 in out 1k
C1 out 0 1u
.pac 1k dec 4 10 10k
.end
