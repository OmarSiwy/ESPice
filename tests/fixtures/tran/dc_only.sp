* Source waveform dc_only
* Expected results: dc_only.expected.json
Vin in 0 DC 3
R1 in out 1000
R2 out 0 3000
.tran 1u 0.003 0 1u
.end
