* A PWL past the 64-point source table: later segments chain in series (V) and parallel (I)
* Expected results: pwl_long.expected.json
* Triangle wave, 0 V at even ns and 1 V at odd ns, 151 points (0..150 ns). A
* truncated table would hold 1 V from 63 ns on. Oracle: analytic, the
* waveform itself at mid-segment and late times.
V1 a 0 PWL(0n 0 1n 1 2n 0 3n 1 4n 0 5n 1 6n 0 7n 1 8n 0 9n 1 10n 0 11n 1 12n 0 13n 1 14n 0 15n 1 16n 0 17n 1 18n 0 19n 1 20n 0 21n 1 22n 0 23n 1 24n 0 25n 1 26n 0 27n 1 28n 0 29n 1 30n 0 31n 1 32n 0 33n 1 34n 0 35n 1 36n 0 37n 1 38n 0 39n 1 40n 0 41n 1 42n 0 43n 1 44n 0 45n 1 46n 0 47n 1 48n 0 49n 1 50n 0 51n 1 52n 0 53n 1 54n 0 55n 1 56n 0 57n 1 58n 0 59n 1 60n 0 61n 1 62n 0 63n 1 64n 0 65n 1 66n 0 67n 1 68n 0 69n 1 70n 0 71n 1 72n 0 73n 1 74n 0 75n 1 76n 0 77n 1 78n 0 79n 1 80n 0 81n 1 82n 0 83n 1 84n 0 85n 1 86n 0 87n 1 88n 0 89n 1 90n 0 91n 1 92n 0 93n 1 94n 0 95n 1 96n 0 97n 1 98n 0 99n 1 100n 0 101n 1 102n 0 103n 1 104n 0 105n 1 106n 0 107n 1 108n 0 109n 1 110n 0 111n 1 112n 0 113n 1 114n 0 115n 1 116n 0 117n 1 118n 0 119n 1 120n 0 121n 1 122n 0 123n 1 124n 0 125n 1 126n 0 127n 1 128n 0 129n 1 130n 0 131n 1 132n 0 133n 1 134n 0 135n 1 136n 0 137n 1 138n 0 139n 1 140n 0 141n 1 142n 0 143n 1 144n 0 145n 1 146n 0 147n 1 148n 0 149n 1 150n 0)
R1 a 0 1k
I1 0 b PWL(0n 0m 1n 1m 2n 0m 3n 1m 4n 0m 5n 1m 6n 0m 7n 1m 8n 0m 9n 1m 10n 0m 11n 1m 12n 0m 13n 1m 14n 0m 15n 1m 16n 0m 17n 1m 18n 0m 19n 1m 20n 0m 21n 1m 22n 0m 23n 1m 24n 0m 25n 1m 26n 0m 27n 1m 28n 0m 29n 1m 30n 0m 31n 1m 32n 0m 33n 1m 34n 0m 35n 1m 36n 0m 37n 1m 38n 0m 39n 1m 40n 0m 41n 1m 42n 0m 43n 1m 44n 0m 45n 1m 46n 0m 47n 1m 48n 0m 49n 1m 50n 0m 51n 1m 52n 0m 53n 1m 54n 0m 55n 1m 56n 0m 57n 1m 58n 0m 59n 1m 60n 0m 61n 1m 62n 0m 63n 1m 64n 0m 65n 1m 66n 0m 67n 1m 68n 0m 69n 1m 70n 0m 71n 1m 72n 0m 73n 1m 74n 0m 75n 1m 76n 0m 77n 1m 78n 0m 79n 1m 80n 0m 81n 1m 82n 0m 83n 1m 84n 0m 85n 1m 86n 0m 87n 1m 88n 0m 89n 1m 90n 0m 91n 1m 92n 0m 93n 1m 94n 0m 95n 1m 96n 0m 97n 1m 98n 0m 99n 1m 100n 0m 101n 1m 102n 0m 103n 1m 104n 0m 105n 1m 106n 0m 107n 1m 108n 0m 109n 1m 110n 0m 111n 1m 112n 0m 113n 1m 114n 0m 115n 1m 116n 0m 117n 1m 118n 0m 119n 1m 120n 0m 121n 1m 122n 0m 123n 1m 124n 0m 125n 1m 126n 0m 127n 1m 128n 0m 129n 1m 130n 0m 131n 1m 132n 0m 133n 1m 134n 0m 135n 1m 136n 0m 137n 1m 138n 0m 139n 1m 140n 0m 141n 1m 142n 0m 143n 1m 144n 0m 145n 1m 146n 0m 147n 1m 148n 0m 149n 1m 150n 0m)
R2 b 0 1k
.tran 0.1n 150n
.end
