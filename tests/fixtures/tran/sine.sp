* Source waveform sine
* Expected results: sine.expected.json
Vin in 0 SIN(0 2 1k)
R1 in out 1000
R2 out 0 3000
.tran 1u 0.002 0 1u
.end
