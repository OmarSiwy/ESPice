* Source waveform sine_offset_phase
* Expected results: sine_offset_phase.expected.json
Vin in 0 SIN(1 2 1k 0 0 90)
R1 in out 1000
R2 out 0 3000
.tran 1u 0.002 0 1u
.end
