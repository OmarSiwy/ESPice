* Source waveform pwl_nonzero_start
* Expected results: pwl_nonzero_start.expected.json
Vin in 0 PWL(0 3 1m 3 2m 1 3m 1)
R1 in out 1000
R2 out 0 3000
.tran 1u 0.003 0 1u
.end
