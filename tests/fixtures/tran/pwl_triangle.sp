* Source waveform pwl_triangle
* Expected results: pwl_triangle.expected.json
Vin in 0 PWL(0 0 1m 2 2m -2 3m 0)
R1 in out 1000
R2 out 0 3000
.tran 1u 0.003 0 1u
.end
