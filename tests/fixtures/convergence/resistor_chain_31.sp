* 31-resistor chain; sparse solve and accumulated residual
* Expected results: resistor_chain_31.expected.json
Vin in 0 1
R1 in n1 1k
R2 n1 n2 1k
R3 n2 n3 1k
R4 n3 n4 1k
R5 n4 n5 1k
R6 n5 n6 1k
R7 n6 n7 1k
R8 n7 n8 1k
R9 n8 n9 1k
R10 n9 n10 1k
R11 n10 n11 1k
R12 n11 n12 1k
R13 n12 n13 1k
R14 n13 n14 1k
R15 n14 n15 1k
R16 n15 n16 1k
R17 n16 n17 1k
R18 n17 n18 1k
R19 n18 n19 1k
R20 n19 n20 1k
R21 n20 n21 1k
R22 n21 n22 1k
R23 n22 n23 1k
R24 n23 n24 1k
R25 n24 n25 1k
R26 n25 n26 1k
R27 n26 n27 1k
R28 n27 n28 1k
R29 n28 n29 1k
R30 n29 n30 1k
R31 n30 0 1k
.op
.end
