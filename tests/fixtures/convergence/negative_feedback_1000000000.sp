* Finite-gain voltage follower A=1e+09
* Expected results: negative_feedback_1000000000.expected.json
Vin in 0 1
Eamp out 0 in out 1000000000.0
Rload out 0 1k
.op
.end
