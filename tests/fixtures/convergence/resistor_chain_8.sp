* 8-resistor chain; sparse solve and accumulated residual
* Expected results: resistor_chain_8.expected.json
Vin in 0 1
R1 in n1 1k
R2 n1 n2 1k
R3 n2 n3 1k
R4 n3 n4 1k
R5 n4 n5 1k
R6 n5 n6 1k
R7 n6 n7 1k
R8 n7 0 1k
.op
.end
