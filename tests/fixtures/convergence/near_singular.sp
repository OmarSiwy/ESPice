* Nearly Singular Matrix Test
*
* Three resistors in a near-degenerate configuration
* Very small and very large resistance values create
* extreme condition number in the MNA matrix
* Tests pivoting strategy and numerical precision

V1 in 0 DC 1
R1 in mid 0.001
R2 mid out 1e9
R3 out 0 1

.OP

.END
