* 257-resistor chain; sparse solve and accumulated residual
* Expected results: resistor_chain_257.expected.json
Vin in 0 1
R1 in n1 1k
R2 n1 n2 1k
R3 n2 n3 1k
R4 n3 n4 1k
R5 n4 n5 1k
R6 n5 n6 1k
R7 n6 n7 1k
R8 n7 n8 1k
R9 n8 n9 1k
R10 n9 n10 1k
R11 n10 n11 1k
R12 n11 n12 1k
R13 n12 n13 1k
R14 n13 n14 1k
R15 n14 n15 1k
R16 n15 n16 1k
R17 n16 n17 1k
R18 n17 n18 1k
R19 n18 n19 1k
R20 n19 n20 1k
R21 n20 n21 1k
R22 n21 n22 1k
R23 n22 n23 1k
R24 n23 n24 1k
R25 n24 n25 1k
R26 n25 n26 1k
R27 n26 n27 1k
R28 n27 n28 1k
R29 n28 n29 1k
R30 n29 n30 1k
R31 n30 n31 1k
R32 n31 n32 1k
R33 n32 n33 1k
R34 n33 n34 1k
R35 n34 n35 1k
R36 n35 n36 1k
R37 n36 n37 1k
R38 n37 n38 1k
R39 n38 n39 1k
R40 n39 n40 1k
R41 n40 n41 1k
R42 n41 n42 1k
R43 n42 n43 1k
R44 n43 n44 1k
R45 n44 n45 1k
R46 n45 n46 1k
R47 n46 n47 1k
R48 n47 n48 1k
R49 n48 n49 1k
R50 n49 n50 1k
R51 n50 n51 1k
R52 n51 n52 1k
R53 n52 n53 1k
R54 n53 n54 1k
R55 n54 n55 1k
R56 n55 n56 1k
R57 n56 n57 1k
R58 n57 n58 1k
R59 n58 n59 1k
R60 n59 n60 1k
R61 n60 n61 1k
R62 n61 n62 1k
R63 n62 n63 1k
R64 n63 n64 1k
R65 n64 n65 1k
R66 n65 n66 1k
R67 n66 n67 1k
R68 n67 n68 1k
R69 n68 n69 1k
R70 n69 n70 1k
R71 n70 n71 1k
R72 n71 n72 1k
R73 n72 n73 1k
R74 n73 n74 1k
R75 n74 n75 1k
R76 n75 n76 1k
R77 n76 n77 1k
R78 n77 n78 1k
R79 n78 n79 1k
R80 n79 n80 1k
R81 n80 n81 1k
R82 n81 n82 1k
R83 n82 n83 1k
R84 n83 n84 1k
R85 n84 n85 1k
R86 n85 n86 1k
R87 n86 n87 1k
R88 n87 n88 1k
R89 n88 n89 1k
R90 n89 n90 1k
R91 n90 n91 1k
R92 n91 n92 1k
R93 n92 n93 1k
R94 n93 n94 1k
R95 n94 n95 1k
R96 n95 n96 1k
R97 n96 n97 1k
R98 n97 n98 1k
R99 n98 n99 1k
R100 n99 n100 1k
R101 n100 n101 1k
R102 n101 n102 1k
R103 n102 n103 1k
R104 n103 n104 1k
R105 n104 n105 1k
R106 n105 n106 1k
R107 n106 n107 1k
R108 n107 n108 1k
R109 n108 n109 1k
R110 n109 n110 1k
R111 n110 n111 1k
R112 n111 n112 1k
R113 n112 n113 1k
R114 n113 n114 1k
R115 n114 n115 1k
R116 n115 n116 1k
R117 n116 n117 1k
R118 n117 n118 1k
R119 n118 n119 1k
R120 n119 n120 1k
R121 n120 n121 1k
R122 n121 n122 1k
R123 n122 n123 1k
R124 n123 n124 1k
R125 n124 n125 1k
R126 n125 n126 1k
R127 n126 n127 1k
R128 n127 n128 1k
R129 n128 n129 1k
R130 n129 n130 1k
R131 n130 n131 1k
R132 n131 n132 1k
R133 n132 n133 1k
R134 n133 n134 1k
R135 n134 n135 1k
R136 n135 n136 1k
R137 n136 n137 1k
R138 n137 n138 1k
R139 n138 n139 1k
R140 n139 n140 1k
R141 n140 n141 1k
R142 n141 n142 1k
R143 n142 n143 1k
R144 n143 n144 1k
R145 n144 n145 1k
R146 n145 n146 1k
R147 n146 n147 1k
R148 n147 n148 1k
R149 n148 n149 1k
R150 n149 n150 1k
R151 n150 n151 1k
R152 n151 n152 1k
R153 n152 n153 1k
R154 n153 n154 1k
R155 n154 n155 1k
R156 n155 n156 1k
R157 n156 n157 1k
R158 n157 n158 1k
R159 n158 n159 1k
R160 n159 n160 1k
R161 n160 n161 1k
R162 n161 n162 1k
R163 n162 n163 1k
R164 n163 n164 1k
R165 n164 n165 1k
R166 n165 n166 1k
R167 n166 n167 1k
R168 n167 n168 1k
R169 n168 n169 1k
R170 n169 n170 1k
R171 n170 n171 1k
R172 n171 n172 1k
R173 n172 n173 1k
R174 n173 n174 1k
R175 n174 n175 1k
R176 n175 n176 1k
R177 n176 n177 1k
R178 n177 n178 1k
R179 n178 n179 1k
R180 n179 n180 1k
R181 n180 n181 1k
R182 n181 n182 1k
R183 n182 n183 1k
R184 n183 n184 1k
R185 n184 n185 1k
R186 n185 n186 1k
R187 n186 n187 1k
R188 n187 n188 1k
R189 n188 n189 1k
R190 n189 n190 1k
R191 n190 n191 1k
R192 n191 n192 1k
R193 n192 n193 1k
R194 n193 n194 1k
R195 n194 n195 1k
R196 n195 n196 1k
R197 n196 n197 1k
R198 n197 n198 1k
R199 n198 n199 1k
R200 n199 n200 1k
R201 n200 n201 1k
R202 n201 n202 1k
R203 n202 n203 1k
R204 n203 n204 1k
R205 n204 n205 1k
R206 n205 n206 1k
R207 n206 n207 1k
R208 n207 n208 1k
R209 n208 n209 1k
R210 n209 n210 1k
R211 n210 n211 1k
R212 n211 n212 1k
R213 n212 n213 1k
R214 n213 n214 1k
R215 n214 n215 1k
R216 n215 n216 1k
R217 n216 n217 1k
R218 n217 n218 1k
R219 n218 n219 1k
R220 n219 n220 1k
R221 n220 n221 1k
R222 n221 n222 1k
R223 n222 n223 1k
R224 n223 n224 1k
R225 n224 n225 1k
R226 n225 n226 1k
R227 n226 n227 1k
R228 n227 n228 1k
R229 n228 n229 1k
R230 n229 n230 1k
R231 n230 n231 1k
R232 n231 n232 1k
R233 n232 n233 1k
R234 n233 n234 1k
R235 n234 n235 1k
R236 n235 n236 1k
R237 n236 n237 1k
R238 n237 n238 1k
R239 n238 n239 1k
R240 n239 n240 1k
R241 n240 n241 1k
R242 n241 n242 1k
R243 n242 n243 1k
R244 n243 n244 1k
R245 n244 n245 1k
R246 n245 n246 1k
R247 n246 n247 1k
R248 n247 n248 1k
R249 n248 n249 1k
R250 n249 n250 1k
R251 n250 n251 1k
R252 n251 n252 1k
R253 n252 n253 1k
R254 n253 n254 1k
R255 n254 n255 1k
R256 n255 n256 1k
R257 n256 0 1k
.op
.end
