* 32 series junctions
* Expected results: diode_stack_32.expected.json
Vin in 0 20
R1 in n1 1k
D1 n1 n2 dm
D2 n2 n3 dm
D3 n3 n4 dm
D4 n4 n5 dm
D5 n5 n6 dm
D6 n6 n7 dm
D7 n7 n8 dm
D8 n8 n9 dm
D9 n9 n10 dm
D10 n10 n11 dm
D11 n11 n12 dm
D12 n12 n13 dm
D13 n13 n14 dm
D14 n14 n15 dm
D15 n15 n16 dm
D16 n16 n17 dm
D17 n17 n18 dm
D18 n18 n19 dm
D19 n19 n20 dm
D20 n20 n21 dm
D21 n21 n22 dm
D22 n22 n23 dm
D23 n23 n24 dm
D24 n24 n25 dm
D25 n25 n26 dm
D26 n26 n27 dm
D27 n27 n28 dm
D28 n28 n29 dm
D29 n29 n30 dm
D30 n30 n31 dm
D31 n31 n32 dm
D32 n32 0 dm
.model dm D(is=1e-14)
.op
.end
