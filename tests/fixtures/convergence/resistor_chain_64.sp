* 64-resistor chain; sparse solve and accumulated residual
* Expected results: resistor_chain_64.expected.json
Vin in 0 1
R1 in n1 1k
R2 n1 n2 1k
R3 n2 n3 1k
R4 n3 n4 1k
R5 n4 n5 1k
R6 n5 n6 1k
R7 n6 n7 1k
R8 n7 n8 1k
R9 n8 n9 1k
R10 n9 n10 1k
R11 n10 n11 1k
R12 n11 n12 1k
R13 n12 n13 1k
R14 n13 n14 1k
R15 n14 n15 1k
R16 n15 n16 1k
R17 n16 n17 1k
R18 n17 n18 1k
R19 n18 n19 1k
R20 n19 n20 1k
R21 n20 n21 1k
R22 n21 n22 1k
R23 n22 n23 1k
R24 n23 n24 1k
R25 n24 n25 1k
R26 n25 n26 1k
R27 n26 n27 1k
R28 n27 n28 1k
R29 n28 n29 1k
R30 n29 n30 1k
R31 n30 n31 1k
R32 n31 n32 1k
R33 n32 n33 1k
R34 n33 n34 1k
R35 n34 n35 1k
R36 n35 n36 1k
R37 n36 n37 1k
R38 n37 n38 1k
R39 n38 n39 1k
R40 n39 n40 1k
R41 n40 n41 1k
R42 n41 n42 1k
R43 n42 n43 1k
R44 n43 n44 1k
R45 n44 n45 1k
R46 n45 n46 1k
R47 n46 n47 1k
R48 n47 n48 1k
R49 n48 n49 1k
R50 n49 n50 1k
R51 n50 n51 1k
R52 n51 n52 1k
R53 n52 n53 1k
R54 n53 n54 1k
R55 n54 n55 1k
R56 n55 n56 1k
R57 n56 n57 1k
R58 n57 n58 1k
R59 n58 n59 1k
R60 n59 n60 1k
R61 n60 n61 1k
R62 n61 n62 1k
R63 n62 n63 1k
R64 n63 0 1k
.op
.end
