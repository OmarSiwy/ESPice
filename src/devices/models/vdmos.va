// VDMOS — vertical power MOSFET (ngspice letter M, .model vdmos/vdmosn/vdmosp).
// docs/vdmos.md §1 (spec) and §3 (CPU pseudo-code) are the normative source;
// the body diode is docs/diode.md (pulled in by §1.3) and the parameter
// names/units/defaults are ngspice's.
//
// Topology (§1.1): D-RD-d', G-RG-g', S-RS-s'; channel d''-s' driven by
// v(g's'); body diode s'->b' with RB from b' to d'; fixed RDS shunt and GMIN
// across d'-s'. d'' is the quasi-saturation node: §1.2 asks for RQ as a
// "bias-dependent series drop R_Q/(1+v_ds/V_Q)-form in the drain path", which
// is a real series element, so it gets a real node (collapsed when RQ = 0).
// Channel is the MOS1 three-region core with the §1.2 power-MOS extensions
// (mobility degradation THETA, triode shaping MTRIODE, smooth subthreshold
// KSUBTHRES/SUBSHIFT) plus the §1.4 tanh Miller capacitance.
//
// ponytail: no self-heating node (§1.1 calls RTHJC/RTHCA/CTHJ "the
// electro-thermal variant" — that is a second module, not this one) and no
// noise sources (the noise table is flagged *derived*, unverified against
// vdmosnoi.c, and no sibling model in models/ carries noise yet); the four
// parameters are still declared so cards carrying them bind.
//
// Junction / fetlim limiting and the MODEINITJCT seed (§2, diode.md §1.5/§1.6)
// are spelled with $limit as in models/diode.va and models/mos1.va: $limit
// stays the identity inside eval, and VerA's contract `limit`/`seed` hooks
// hand the host the clamps to run between the linear solve and the next eval.
module vdmos(d, g, s);
    inout d, g, s;
    electrical d, g, s;
    electrical dp, gp, sp, bp, dq;
    // Series resistances collapse to a short when the parameter is 0 (§2),
    // which needs a branch that can carry a voltage contribution.
    branch (d, dp) br_rd;
    branch (g, gp) br_rg;
    branch (s, sp) br_rs;
    branch (bp, dp) br_rb;
    branch (dp, dq) br_rq;

    // +1 = vdmosn, -1 = vdmosp: ngspice picks the polarity by model name, the
    // eval maps every internal voltage through it (§3 `ty`).
    parameter integer ty = 1 from [-1:1] exclude 0;

    // --- channel -----------------------------------------------------------
    parameter real vto    = 0.0  ;             // threshold voltage [V]
    parameter real kp     = 1.0  from (0:inf); // transconductance [A/V^2]
    parameter real lambda = 0.0  from [0:inf); // channel-length modulation [1/V]
    parameter real theta  = 0.0  from [0:inf); // mobility degradation [1/V]
    parameter real mtriode = 1.0 from (0:inf); // triode-region conductance knob
    parameter real ksubthres = 0.1 from (0:inf); // subthreshold width [V]
    parameter real subshift  = 0.0;            // subthreshold shift [V]
    parameter real rq = 0.0 from [0:inf);      // quasi-sat series R [ohm], 0 = off
    parameter real vq = 1.0 from (0:inf);      // quasi-sat knee voltage [V]

    // --- resistances (0 = collapsed, rds 0 = infinite) ---------------------
    parameter real rd  = 0.0 from [0:inf);
    parameter real rg  = 0.0 from [0:inf);
    parameter real rs  = 0.0 from [0:inf);
    parameter real rb  = 0.0 from [0:inf);
    parameter real rds = 0.0 from [0:inf);     // drain-source shunt [ohm]
    parameter real gmin = 1e-12 from [0:inf);

    // --- body diode (§1.3, laws per diode.md) ------------------------------
    parameter real is  = 1e-14 from (0:inf);
    parameter real n   = 1.0   from (0:inf);
    parameter real bv  = 0.0   from [0:inf);   // reverse breakdown [V], 0 = none
    parameter real ibv = 1e-10 from [0:inf);   // current at bv [A]
    parameter real nbv = 1.0   from (0:inf);
    parameter real cjo = 0.0   from [0:inf);
    parameter real vj  = 0.8   from (0:inf);
    parameter real mj  = 0.5   from (0:1);
    parameter real fc  = 0.5   from (0:1);
    parameter real tt  = 0.0   from [0:inf);   // transit time [s]
    parameter real eg  = 1.11  from (0:inf);   // IS activation energy [eV]
    parameter real xti = 3.0   from [0:inf);

    // --- gate capacitances (§1.4) ------------------------------------------
    parameter real cgs    = 0.0 from [0:inf);
    parameter real cgdmin = 0.0 from [0:inf);
    parameter real cgdmax = 0.0 from [0:inf);
    parameter real a      = 1.0 from (0:inf);  // Cgd transition steepness [1/V]

    // --- temperature (§1.5) ------------------------------------------------
    parameter real tnom  = $simparam("tnom");               // [degC], ngspice TNOM
    parameter real tcvth = 0.0;                // dVTO/dT [V/K]
    parameter real mu    = -1.5;               // KP ~ (T/Tnom)^MU
    parameter real texp0 = 0.0;                // RD(on) temperature exponent
    parameter real texp1 = 0.0;                // RS(on) temperature exponent
    parameter real trd1 = 0.0;  parameter real trd2 = 0.0;
    parameter real trg1 = 0.0;  parameter real trg2 = 0.0;
    parameter real trs1 = 0.0;  parameter real trs2 = 0.0;
    parameter real trb1 = 0.0;  parameter real trb2 = 0.0;
    parameter real tksubthres1 = 0.0;
    parameter real tksubthres2 = 0.0;

    // --- declared for card binding only (see header) -----------------------
    parameter real rthjc = 0.0 from [0:inf);   // §1.1 electro-thermal variant
    parameter real rthca = 0.0 from [0:inf);
    parameter real cthj  = 0.0 from [0:inf);
    parameter real kf    = 0.0 from [0:inf);   // noise table (host-side)
    parameter real af    = 1.0 from (0:inf);

    // --- instance ----------------------------------------------------------
    // §1.2: beta = KP*W/(L-2*LD)*m. Defaults make W/(L-2LD) = 1 so a
    // datasheet-fitted KP card (no W/L given) keeps meaning KP itself.
    parameter real w  = 1.0 from (0:inf);      // m  channel width
    parameter real l  = 1.0 from (0:inf);      // m  drawn channel length
    parameter real ld = 0.0 from [0:inf);      // m  lateral diffusion
    parameter real m  = 1.0 from (0:inf);      // multiplicity

    // bias-independent (temperature/parameter prep, §5 of the eval contract)
    real tk, tnomk, ratio, dt, vt, vtnom, leff;
    real egfet, egfet1, fact1, fact2, arg1, argt, pbfact, pbfact1;
    real pbo, gmaold, gmanew;
    real vto_t, beta_t, ksub_t;
    real rd_t, rg_t, rs_t, rb_t;
    real is_t, vj_t, cjo_t, fcvj, f1, f2, f3, vte, vtebrk, cbv, xbv;
    real cgdd, tyf, vcritb;
    // bias-dependent
    real vgs, vds, vdsi, vgd, vgdi, msign, vdse, vgst, vgste, sarg, betaeff;
    real vknee, idch;
    real vd, ibd, qbd, arg, argc, qgd, ax, axa, lncosh;

    // §1.5 resistance temperature curve: quadratic in dT times a (T/Tnom)
    // exponent, floored. ngspice clamps a resistance that the curve drove to
    // zero or negative; without the floor the stamps below divide by <= 0.
    analog function real rtemp;
        input r, tc1, tc2, dtx, ratiox, ex;
        real r, tc1, tc2, dtx, ratiox, ex;
        real rr;
        begin
            rr = r * (1.0 + tc1 * dtx + tc2 * dtx * dtx) * pow(ratiox, ex);
            if (rr < 1.0e-9) rr = 1.0e-9;
            rtemp = rr;
        end
    endfunction

    analog begin
        // ---- bias-independent prep -----------------------------------------
        tk = $temperature;
        tnomk = tnom + 273.15;
        ratio = tk / tnomk;
        dt = tk - tnomk;
        vt = 1.380649e-23 * tk / 1.602176634e-19;
        vtnom = 1.380649e-23 * tnomk / 1.602176634e-19;

        // §1.5 threshold, mapped through ty: an ngspice vdmosp card carries a
        // negative Vto and the whole channel is evaluated in the ty frame
        // (§3), so the threshold has to enter that frame too — same as
        // models/mos1.va's `von = vbit*type + ...`.
        vto_t = ty * (vto - tcvth * dt);
        leff = l - 2.0 * ld;
        // ponytail: silent clamp, no diagnostics channel in this frontend
        // (models/mos1.va does the same for LD >= L/2).
        if (leff < 1.0e-10) leff = 1.0e-10;
        beta_t = kp * pow(ratio, mu) * m * w / leff;    // §1.2
        ksub_t = ksubthres * (1.0 + tksubthres1 * dt + tksubthres2 * dt * dt);

        // TEXP0/TEXP1 shape the RDS(on) curve (§1.5), i.e. the on-resistance
        // path: TEXP0 on RD, TEXP1 on RS. The fixed d'-s' shunt RDS of §1.1 is
        // a leakage element and §1.5 gives it no coefficient, so it is flat.
        rd_t = rtemp(rd, trd1, trd2, dt, ratio, texp0);
        rg_t = rtemp(rg, trg1, trg2, dt, ratio, 0.0);
        rs_t = rtemp(rs, trs1, trs2, dt, ratio, texp1);
        rb_t = rtemp(rb, trb1, trb2, dt, ratio, 0.0);

        // ---- body-diode temperature (diode.md §1.2) ------------------------
        // IS(T) uses the EG *parameter* (activation energy) ...
        is_t = is * m * exp((ratio - 1.0) * eg / (n * vt) + (xti / n) * ln(ratio));
        // ... while VJ(T) and CJ0(T) use the temperature-dependent silicon
        // bandgap through the pbfact/pbo construction referred to 300.15 K.
        // Same code as models/mos1.va (`pbfact1/pbfact/pbo/pbt`, `cfb`).
        egfet1 = 1.16 - (7.02e-4 * tnomk * tnomk) / (tnomk + 1108.0);
        egfet  = 1.16 - (7.02e-4 * tk * tk) / (tk + 1108.0);
        fact1 = tnomk / 300.15;
        fact2 = tk / 300.15;
        arg1 = -egfet1 / (2.0 * 1.380649e-23 * tnomk)
             + 1.1150877 / (2.0 * 1.380649e-23 * 300.15);
        argt = -egfet / (2.0 * 1.380649e-23 * tk)
             + 1.1150877 / (2.0 * 1.380649e-23 * 300.15);
        pbfact1 = -2.0 * vtnom * (1.5 * ln(fact1) + 1.602176634e-19 * arg1);
        pbfact  = -2.0 * vt * (1.5 * ln(fact2) + 1.602176634e-19 * argt);
        pbo = (vj - pbfact1) / fact1;
        vj_t = fact2 * pbo + pbfact;
        gmaold = (vj - pbo) / pbo;
        gmanew = (vj_t - pbo) / pbo;
        cjo_t = cjo * m * (1.0 + mj * (4.0e-4 * (tk - 300.15) - gmanew))
                         / (1.0 + mj * (4.0e-4 * (tnomk - 300.15) - gmaold));

        vte = n * vt;
        vtebrk = nbv * vt;
        fcvj = fc * vj_t;
        f1 = vj_t * (1.0 - pow(1.0 - fc, 1.0 - mj)) / (1.0 - mj);
        f2 = pow(1.0 - fc, 1.0 + mj);              // diode.md §1.2: e^{(1+M)*x_fc}
        f3 = 1.0 - fc * (1.0 + mj);

        // Breakdown matching (diode.md §1.2): solve the effective x_bv so the
        // breakdown exponential passes through (-x_bv, -c_bv). BV(T) = BV: §1.5
        // gives VDMOS no BV temperature coefficient (there is no TCV parameter),
        // so the tlev=0 form BV - t_cv*dT degenerates to BV.
        // ponytail: fixed 25 sweeps, no tolerance early-exit — 25 is the doc's
        // iteration cap, it converges in ~3, and this is bias-independent prep.
        // The ln argument stays > 1 (x_bv < BV and c_bv/IS > BV/Vt in this arm),
        // so it is always in range.
        xbv = 0.0;
        if (bv > 0.0) begin
            cbv = ibv;
            if (cbv < is_t * bv / vt) begin
                cbv = is_t * bv / vt;
                xbv = bv;
            end else begin
                xbv = bv - vtebrk * ln(1.0 + cbv / is_t);
                repeat (25)
                    xbv = bv - vtebrk * ln(cbv / is_t + 1.0 - xbv / vt);
            end
        end

        cgdd = 0.5 * (cgdmax - cgdmin);                 // §1.4 tanh amplitude

        // ---- terminal resistances (collapse when the parameter is 0) -------
        // The guard is on the raw parameter: node collapse is a topology
        // decision, so it must not depend on temperature. The divisor is the
        // floored rtemp() value, which is never <= 0.
        if (rd > 0.0) I(br_rd) <+ m * V(br_rd) / rd_t; else V(br_rd) <+ 0.0;
        if (rg > 0.0) I(br_rg) <+ m * V(br_rg) / rg_t; else V(br_rg) <+ 0.0;
        if (rs > 0.0) I(br_rs) <+ m * V(br_rs) / rs_t; else V(br_rs) <+ 0.0;
        if (rb > 0.0) I(br_rb) <+ m * V(br_rb) / rb_t; else V(br_rb) <+ 0.0;

        // ---- channel, §3, §2 limited (mos1.va's ladder) --------------------
        // fetlim on both channel gate legs, limvds on the channel Vds, pnjlim
        // on the body diode below. vto_t is already the ty-frame threshold;
        // trailing tyf = VerA frame sign (vdmosp limits ty·v), and tyf is ty
        // as a real — integer $limit args are declined.
        tyf  = ty;
        vgs  = ty * $limit(V(gp, sp), "fetlim", vto_t, tyf);
        vgdi = ty * $limit(V(gp, dq), "fetlim", vto_t, tyf);
        vdsi = ty * $limit(V(dq, sp), "limvds", tyf);  // seen by the channel
        vds  = ty * V(dp, sp);                     // across the whole drain path
        vgd  = vgs - vds;
        vgdi = vgs - vdsi;

        // Quasi-saturation (§1.2): the epi-layer drop, a real series element
        // R_Q(v_ds) = RQ/(1 + |v_ds|/VQ) between d' and d''. Written as the
        // conductance (1 + |v_ds|/VQ)/RQ so it is finite and strictly positive
        // at every bias (|v_ds| keeps it a resistor in the swapped mode too).
        if (rq > 0.0) I(br_rq) <+ m * V(br_rq) * (1.0 + abs(vds) / vq) / rq;
        else V(br_rq) <+ 0.0;

        // Mode swap as MOS1: source and drain exchange roles for vds < 0.
        if (vdsi >= 0.0) begin
            msign = 1.0;
            vdse = vdsi;
            vgst = vgs - vto_t;
        end else begin
            msign = -1.0;
            vdse = -vdsi;
            vgst = vgdi - vto_t;
        end

        // Smooth subthreshold overdrive: ksub*ln(1+exp(x/ksub)) -> x for x>>0,
        // the large-argument arm only avoids exp() overflow (error < 1e-13).
        sarg = (vgst - subshift) / ksub_t;
        if (sarg > 30.0)
            vgste = vgst - subshift;
        else
            vgste = ksub_t * ln(1.0 + exp(sarg));

        betaeff = beta_t / (1.0 + theta * vgste);        // mobility degradation

        // Three-region core. MTRIODE scales the linear-region conductance and
        // pulls the knee to vgste/mtriode, which keeps I and dI/dvds continuous.
        vknee = vgste / mtriode;
        if (vdse < vknee)
            idch = betaeff * mtriode * vdse * (vgste - 0.5 * mtriode * vdse);
        else
            idch = 0.5 * betaeff * vgste * vgste;
        idch = idch * (1.0 + lambda * vdse);

        I(dq, sp) <+ ty * msign * idch;
        if (rds > 0.0) I(dp, sp) <+ m * V(dp, sp) / rds;
        I(dp, sp) <+ gmin * V(dp, sp);

        // ---- body diode s'->b' (RB carries it on to d') --------------------
        // diode.md §1.3, all three regions: Shockley forward, the smooth cubic
        // deep-reverse branch (C1 with the forward branch at -3*Vte, and its
        // conductance does not collapse to gmin while blocking), and the
        // breakdown exponential below -x_bv. pnjlim'd as in diode.va, with
        // vcrit = vte*ln(vte/(sqrt(2)*Is)); limexp is already tangent-
        // continued, so no flat-clamp hazard in either exponential.
        vcritb = vte * ln(vte / (1.4142135623730951 * is_t));
        vd = ty * $limit(V(sp, bp), "pnjlim", vte, vcritb, tyf);
        if (vd >= -3.0 * vte)
            ibd = is_t * (limexp(vd / vte) - 1.0);
        else if (bv <= 0.0 || vd >= -xbv) begin
            argc = 3.0 * vte / (vd * 2.718281828459045);
            ibd = -is_t * (1.0 + argc * argc * argc);
        end else
            ibd = -is_t * limexp(-(xbv + vd) / vtebrk);
        ibd = ibd + gmin * vd;

        if (vd < fcvj) begin
            arg = 1.0 - vd / vj_t;
            qbd = cjo_t * vj_t * (1.0 - pow(arg, 1.0 - mj)) / (1.0 - mj);
        end else begin
            qbd = cjo_t * f1 + cjo_t / f2 *
                  (f3 * (vd - fcvj) + 0.5 * mj / vj_t * (vd * vd - fcvj * fcvj));
        end
        qbd = qbd + tt * ibd;                            // diffusion charge
        I(sp, bp) <+ ty * ibd + ty * ddt(qbd);

        // ---- gate charges, §1.4 --------------------------------------------
        // q_gd = integral of cgdmin + cgdd*(1+tanh(a*vgd)); the tanh integrates
        // to ln(cosh(a*vgd))/a, written overflow-free as |x|+ln1p(e^-2|x|)-ln2.
        ax = a * vgd;
        axa = abs(ax);
        lncosh = axa + ln1p(exp(-2.0 * axa)) - 0.6931471805599453;
        qgd = cgdmin * vgd + cgdd * (vgd + lncosh / a);

        I(gp, sp) <+ ty * ddt(m * cgs * vgs);
        I(gp, dp) <+ ty * ddt(m * qgd);
    end
endmodule
