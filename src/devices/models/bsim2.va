// BSIM2 — Berkeley Short-channel IGFET Model 2 (ngspice letter M, level 5).
// docs/mos-legacy.md §1.5 (structure) + §3 (MOS1 chassis + level channel block).
//
// Reference: mos-legacy.md names our bsim2.zig port as operative, but that port
// was deleted in the devices refactor (last seen at 9433f48) and, where the two
// disagreed, it was the party in error — so this file is now the single source
// and the equation chain below is transcribed from the real thing:
// ngspice src/spicelib/devices/bsim2/{b2eval.c,b2temp.c,b2ld.c} (fetched
// 2026-07-25). Every place this file departs from the old port is flagged
// `// port:` inline.
//
// Topology (MOS1 chassis, mos1-shichman-hodges.md §1.8):
//     d --[RD]-- dp --[channel]-- sp --[RS]-- s
//     bulk diodes b-dp / b-sp, charge-based gate/channel charges (§2: "BSIM1/2
//     replace Meyer caps with their own charge equations")
//
// BSIM2 is an extraction-era model: every coefficient comes from the card, and
// each core coefficient carries L- and W-sensitivity siblings combined as
// P_eff = P0 + PL/Leff_um + PW/Weff_um (the Berkeley "W/L decomposition",
// b2temp.c). That decomposition, the oxide cap, the thermal voltage and the
// effective geometry are all bias-independent, so they are computed once at the
// top of the analog block, ahead of every V() read (§5 of the eval contract).
//
// Structure of the channel block (b2eval.c), which is *one* equation, not a
// region ladder: the gate drive Vgst = Vgs - Vth is mapped through Vgeff, which
// is Vgst in strong inversion, an exponential in weak inversion, and a
// C1-continuous cubic between the VGLOW/VGHIGH knots — that Vgg/Vgt transition
// is the refinement doc §1.5 names as BSIM2's defining feature over BSIM1, and
// it is what makes the subthreshold current *additive-equivalent* (it enters
// the same Ids expression) instead of a multiplicative fudge factor.
//
// fetlim/limvds/pnjlim are spelled with $limit as in models/mos1.va and the
// rest of the legacy-MOS family: $limit stays the identity inside eval, and
// VerA's contract `limit`/`seed` hooks hand the host the clamps to run
// between the linear solve and the next eval.
module bsim2(d, g, s, b);
    inout d, g, s, b;
    electrical d, g, s, b;
    electrical dp, sp;                      // intrinsic drain / source

    // --- device type ------------------------------------------------------
    parameter integer type_ = 1 from [-1:1] exclude 0;  // +1 NMOS, -1 PMOS

    // --- threshold voltage ------------------------------------------------
    parameter real vfb  = -1.0;   // flat-band voltage [V]
    parameter real lvfb = 0.0;
    parameter real wvfb = 0.0;
    parameter real phi  = 0.75;   // strong-inversion surface potential [V]
    parameter real lphi = 0.0;
    parameter real wphi = 0.0;
    parameter real k1   = 0.8;    // bulk-effect coefficient 1 [V^0.5]
    parameter real lk1  = 0.0;
    parameter real wk1  = 0.0;
    parameter real k2   = 0.0;    // bulk-effect coefficient 2
    parameter real lk2  = 0.0;
    parameter real wk2  = 0.0;
    parameter real eta0 = 0.0;    // vds dependence of vth (DIBL)
    parameter real leta0 = 0.0;
    parameter real weta0 = 0.0;
    parameter real etab = 0.0;    // vbs dependence of eta
    parameter real letab = 0.0;
    parameter real wetab = 0.0;

    // --- geometry ---------------------------------------------------------
    parameter real dl  = 0.0;     // channel length reduction [um]
    parameter real dw  = 0.0;     // channel width reduction [um]
    parameter real ld  = 0.0;     // lateral diffusion [m] (card carry-through)
    parameter real tox = 0.03 from (0:inf);  // gate oxide thickness [um]

    // --- mobility ---------------------------------------------------------
    parameter real mu0  = 400.0;  // low-field mobility at vds = 0 [cm^2/V/s]
    parameter real mu0b = 0.0;    // vbs dependence of mu0
    parameter real lmu0b = 0.0;
    parameter real wmu0b = 0.0;
    parameter real mus0 = 500.0;  // mobility at vds = vdd [cm^2/V/s]
    parameter real lmus0 = 0.0;
    parameter real wmus0 = 0.0;
    parameter real musb = 0.0;    // vbs dependence of mus
    parameter real lmusb = 0.0;
    parameter real wmusb = 0.0;
    parameter real mu20 = 1.5;    // vds dependence of mu, tanh term (unitless)
    parameter real lmu20 = 0.0;
    parameter real wmu20 = 0.0;
    parameter real mu2b = 0.0;
    parameter real lmu2b = 0.0;
    parameter real wmu2b = 0.0;
    parameter real mu2g = 0.0;
    parameter real lmu2g = 0.0;
    parameter real wmu2g = 0.0;
    parameter real mu30 = 10.0;   // vds dependence of mu, linear term
    parameter real lmu30 = 0.0;
    parameter real wmu30 = 0.0;
    parameter real mu3b = 0.0;
    parameter real lmu3b = 0.0;
    parameter real wmu3b = 0.0;
    parameter real mu3g = 0.0;
    parameter real lmu3g = 0.0;
    parameter real wmu3g = 0.0;
    parameter real mu40 = 0.0;    // vds dependence of mu, quadratic term
    parameter real lmu40 = 0.0;
    parameter real wmu40 = 0.0;
    parameter real mu4b = 0.0;
    parameter real lmu4b = 0.0;
    parameter real wmu4b = 0.0;
    parameter real mu4g = 0.0;
    parameter real lmu4g = 0.0;
    parameter real wmu4g = 0.0;

    // --- gate-field mobility degradation ----------------------------------
    parameter real ua0 = 0.2;     // linear vgs degradation [1/V]
    parameter real lua0 = 0.0;
    parameter real wua0 = 0.0;
    parameter real uab = 0.0;
    parameter real luab = 0.0;
    parameter real wuab = 0.0;
    parameter real ub0 = 0.0;     // quadratic vgs degradation [1/V^2]
    parameter real lub0 = 0.0;
    parameter real wub0 = 0.0;
    parameter real ubb = 0.0;
    parameter real lubb = 0.0;
    parameter real wubb = 0.0;

    // --- lateral-field (velocity-saturation) mobility ---------------------
    parameter real u10 = 0.1;     // [1/V]
    parameter real lu10 = 0.0;
    parameter real wu10 = 0.0;
    parameter real u1b = 0.0;     // vbs dependence of u1
    parameter real lu1b = 0.0;
    parameter real wu1b = 0.0;
    parameter real u1d = 0.0;     // triode-region modulation of u1 (unitless)
    parameter real lu1d = 0.0;
    parameter real wu1d = 0.0;

    // --- subthreshold -----------------------------------------------------
    parameter real n0 = 1.4;      // subthreshold slope factor
    parameter real ln0 = 0.0;
    parameter real wn0 = 0.0;
    parameter real nb = 0.5;      // body dependence of n (enters as nb/sqrt(phisb))
    parameter real lnb = 0.0;
    parameter real wnb = 0.0;
    parameter real nd = 0.0;      // vds dependence of n
    parameter real lnd = 0.0;
    parameter real wnd = 0.0;
    parameter real vof0 = 1.8;    // weak-inversion prefactor exponent (unitless)
    parameter real lvof0 = 0.0;
    parameter real wvof0 = 0.0;
    parameter real vofb = 0.0;
    parameter real lvofb = 0.0;
    parameter real wvofb = 0.0;
    parameter real vofd = 0.0;
    parameter real lvofd = 0.0;
    parameter real wvofd = 0.0;

    // --- hot-electron / output conductance --------------------------------
    parameter real ai0 = 0.0;     // pre-factor
    parameter real lai0 = 0.0;
    parameter real wai0 = 0.0;
    parameter real aib = 0.0;
    parameter real laib = 0.0;
    parameter real waib = 0.0;
    parameter real bi0 = 0.0;     // exponential factor [V]
    parameter real lbi0 = 0.0;
    parameter real wbi0 = 0.0;
    parameter real bib = 0.0;
    parameter real lbib = 0.0;
    parameter real wbib = 0.0;

    // --- Vgg/Vgt cubic-spline knots (doc §1.5) ----------------------------
    parameter real vghigh = 0.2;  // upper knot on vgst [V]
    parameter real lvghigh = 0.0;
    parameter real wvghigh = 0.0;
    parameter real vglow = -0.15; // lower knot on vgst [V]
    parameter real lvglow = 0.0;
    parameter real wvglow = 0.0;

    // --- extraction reference bias / nominal temperature ------------------
    // vdd is the Vds *reference point* of the mobility interpolation: the
    // mu0 -> mus endpoint is defined at vds = vdd (b2eval.c Beta1). All three
    // are ALSO hard clamps on the bias triple: b2eval.c:57-59 limits its local
    // Vbs/Vgs/Vds to 2*VBB / 2*VGG / 2*VDD before evaluating anything, and
    // b2temp.c:135-137 uses VBB for the betasB endpoint clamp.
    parameter real vdd = 5.0;     // V
    parameter real vgg = 5.0;     // V
    parameter real vbb = 5.0;     // V (real cards give it negative)
    // b2temp.c: `B2Vtm = 8.625e-5 * (B2temp + 273.0)` — BSIM2 has *no*
    // temperature maps at all (verified: b2temp.c touches neither Eg, pb, js
    // nor the cap factors), and the thermal voltage comes from this model-card
    // parameter, which ngspice spells `temp` in degC. Naming it `tnom` while
    // also declaring a Kelvin instance `temp` (as the old port did) made the
    // card's `temp = 27` bind to the Kelvin slot.
    parameter real temp = 27.0;   // degC, parameter measurement temperature

    // --- capacitances -----------------------------------------------------
    parameter real cgso = 0.0;    // gate-source overlap [F/m]
    parameter real cgdo = 0.0;    // gate-drain overlap [F/m]
    parameter real cgbo = 0.0;    // gate-bulk overlap [F/m]
    parameter integer xpart = 0 from [0:1];   // 0 = 40/60, 1 = 0/100

    // --- junctions --------------------------------------------------------
    parameter real js   = 0.0;    // saturation current density [A/m^2]
    parameter real pb   = 0.8 from (0:inf);   // bottom built-in potential [V]
    parameter real mj   = 0.0;    // bottom grading coefficient
    parameter real pbsw = 0.8 from (0:inf);   // sidewall built-in potential [V]
    parameter real mjsw = 0.0;    // sidewall grading coefficient
    parameter real cj   = 0.0;    // bottom junction cap [F/m^2]
    parameter real cjsw = 0.0;    // sidewall junction cap [F/m]

    // --- parasitic resistance ---------------------------------------------
    parameter real rsh  = 0.0;    // sheet resistance [ohm/sq]
    parameter real wdf  = 10.0;   // default diffusion width [um]
    parameter real dell = 0.0;    // diffusion length reduction [um]

    // --- noise (mos-legacy.md noise table, mos1noi.c template) ------------
    parameter real kf = 0.0;
    parameter real af = 1.0;

    // --- instance ---------------------------------------------------------
    parameter real w = 5e-6 from (0:inf);     // channel width [m]
    parameter real l = 5e-6 from (0:inf);     // channel length [m]
    parameter real m = 1.0 from (0:inf);      // parallel multiplier
    parameter real ad = 0.0 from [0:inf);     // drain diffusion area [m^2]
    parameter real as = 0.0 from [0:inf);     // source diffusion area [m^2]
    parameter real pd = 0.0 from [0:inf);     // drain diffusion perimeter [m]
    parameter real ps = 0.0 from [0:inf);     // source diffusion perimeter [m]
    parameter real nrd = 1.0 from [0:inf);    // squares of drain diffusion
    parameter real nrs = 1.0 from [0:inf);    // squares of source diffusion

    // bias-independent prep
    real leff, weff, lum, wum, il, iw, tabs, vt, cox, coxwl, bfac;
    real adrn, asrc, pdrn, psrc, isd, iss, czbs, czbssw, czbd, czbdsw;
    real gdp, gsp, vddc, vdd2, vgg2, vbb2, tyf, vtx, vcrits, vcritd;
    real vfbe, phie, phis3, k1e, k2e, eta0e, etabe;
    real mu0be, mus0e, musbe;
    real mu20e, mu2be, mu2ge, mu30e, mu3be, mu3ge, mu40e, mu4be, mu4ge;
    real ua0e, uabe, ub0e, ubbe, u10e, u1be, u1de;
    real n0e, nbe, nde, vof0e, vofbe, vofde;
    real ai0e, aibe, bi0e, bibe, vghe, vgle;
    real omj, omjsw;
    // bias-dependent
    real vgsr, vgdr, vdsr, vbsr, vdsn, vbs, vgs, vds, mode, uj;
    real phisb, t1s, eta, vth, vth0, nsub, vof, gg, aa;
    real wds, wpre, vgwk, vglo, slo, hspan, tsp, h00, h10, h01, h11;
    real vgst, vgeff, dvgeff, ua, ub, uvert, u1s, u1, vc, kk, vdsat, vdsch, t4;
    real beta0b, betas, beta1, beta2, beta3, beta4, beta, betaeff, targ;
    real ai, bi, dvds, fclm, idscore, gmch, ids, idst;
    real vbdj, ibs, ibd;
    real qgch, qbch, qdch, qgso, qgdo, qgbo, qbs, qbd;

    // Junction depletion charge, forward/reverse blended by a steep sigmoid
    // (one differentiable expression instead of a v<0 branch). Reverse branch
    // is the integral of the cj/(1-v/pb)^mj law,
    // q = pb*cj/(1-mj) * (1 - (1-v/pb)^(1-mj)), clamped at (1-v/pb) >= 0.01.
    // port: bsim2.zig used (1-v/pb)^(2-mj); b2ld.c has `sarg = arg^(-mj)` and
    // `q = pb*cj*(1 - arg*sarg)/(1-mj)` = the 1-mj exponent below, so the port
    // was the party in error. cja/cjswa are absolute farads (already
    // area/perimeter scaled by the caller).
    analog function real jcharge;
        input v, cja, cjswa, pba, pbswa, mja, mjswa, om, omsw;
        real v, cja, cjswa, pba, pbswa, mja, mjswa, om, omsw;
        real sg, qf, ar, arsw, qr;
        begin
            sg = 0.5 * (1.0 + tanh(max(min(100.0 * v, 30.0), -30.0)));
            qf = v * (cja + cjswa)
                 + v * v * (cja * mja / (2.0 * pba) + cjswa * mjswa / (2.0 * pbswa));
            ar   = max(1.0 - v / pba,   0.01);
            arsw = max(1.0 - v / pbswa, 0.01);
            qr = (pba * cja / om) * (1.0 - pow(ar, om))
                 + (pbswa * cjswa / omsw) * (1.0 - pow(arsw, omsw));
            jcharge = (1.0 - sg) * qr + sg * qf;
        end
    endfunction

    analog begin
        // ==================================================================
        // Bias-independent prep — geometry, temperature, W/L decomposition.
        // Nothing here reads V() (doc §2, eval contract §5).
        // ==================================================================
        leff = max(l - dl * 1.0e-6, 1.0e-9);
        weff = max(w - dw * 1.0e-6, 1.0e-9);
        lum  = max(leff * 1.0e6, 0.01);
        wum  = max(weff * 1.0e6, 0.01);
        il   = 1.0 / lum;
        iw   = 1.0 / wum;

        tabs  = temp + 273.0;                           // b2temp.c, degC -> K
        vt    = 8.625e-5 * tabs;                        // kT/q [V], b2temp.c
        // b2temp.c:44 is `Cox = 3.453e-13 / (B2tox * 1.0e-4)` [F/cm^2] -- eps_ox
        // over TOX read as MICRONS, with no floor. The 1e-12 m guard that used
        // to sit here capped Cox at 1/25 of ngspice's for any card spelling TOX
        // in metres-looking units (devices/bsim2 has TOX=40n -> 4e-14 m), and
        // Ids is exactly linear in Cox. `from (0:inf)` already keeps tox > 0.
        cox   = 3.453e-11 / (tox * 1.0e-6);            // eps_ox/tox [F/m^2]
        coxwl = cox * weff * leff;
        // Gate-drive-independent part of beta: 1e-4 converts cm^2/V/s -> m^2.
        bfac  = 1.0e-4 * cox * weff / leff;

        // P_eff = P0 + PL/Leff_um + PW/Weff_um.
        vfbe  = vfb  + lvfb  * il + wvfb  * iw;
        phie  = max(phi + lphi * il + wphi * iw, 0.1);
        phis3 = phie * sqrt(phie);
        k1e   = k1   + lk1   * il + wk1   * iw;
        k2e   = k2   + lk2   * il + wk2   * iw;
        eta0e = eta0 + leta0 * il + weta0 * iw;
        etabe = etab + letab * il + wetab * iw;

        mu0be = mu0b + lmu0b * il + wmu0b * iw;
        mus0e = mus0 + lmus0 * il + wmus0 * iw;
        musbe = musb + lmusb * il + wmusb * iw;
        // b2temp.c:129-137, on the RAW mobilities and BEFORE the CoxW/L scaling
        // at b2temp.c:168-171:
        //   if (betas0 < 1.01*beta0) betas0 = 1.01*beta0;
        //   tmp = betas0 - beta0 - beta0B*VBB;
        //   if ((-betasB*VBB) > tmp) betasB = -tmp/VBB;
        // beta0 there is the raw MU0 with no L/W siblings, beta0B is mu0be.
        // devices/bsim2 leaves MUS0 at its 500 default under MU0=600, so ngspice
        // actually runs 606 -- a 1.21x on the current all by itself.
        mus0e = max(mus0e, 1.01 * mu0);
        musbe = (vbb != 0.0 && (-musbe * vbb) > (mus0e - mu0 - mu0be * vbb))
                ? -(mus0e - mu0 - mu0be * vbb) / vbb
                : musbe;
        mu20e = mu20 + lmu20 * il + wmu20 * iw;
        mu2be = mu2b + lmu2b * il + wmu2b * iw;
        mu2ge = mu2g + lmu2g * il + wmu2g * iw;
        mu30e = mu30 + lmu30 * il + wmu30 * iw;
        mu3be = mu3b + lmu3b * il + wmu3b * iw;
        mu3ge = mu3g + lmu3g * il + wmu3g * iw;
        mu40e = mu40 + lmu40 * il + wmu40 * iw;
        mu4be = mu4b + lmu4b * il + wmu4b * iw;
        mu4ge = mu4g + lmu4g * il + wmu4g * iw;

        ua0e = ua0 + lua0 * il + wua0 * iw;
        uabe = uab + luab * il + wuab * iw;
        ub0e = ub0 + lub0 * il + wub0 * iw;
        ubbe = ubb + lubb * il + wubb * iw;
        u10e = u10 + lu10 * il + wu10 * iw;
        u1be = u1b + lu1b * il + wu1b * iw;
        u1de = u1d + lu1d * il + wu1d * iw;

        n0e   = n0   + ln0   * il + wn0   * iw;
        nbe   = nb   + lnb   * il + wnb   * iw;
        nde   = nd   + lnd   * il + wnd   * iw;
        vof0e = vof0 + lvof0 * il + wvof0 * iw;
        vofbe = vofb + lvofb * il + wvofb * iw;
        vofde = vofd + lvofd * il + wvofd * iw;

        ai0e = ai0 + lai0 * il + wai0 * iw;
        aibe = aib + laib * il + waib * iw;
        bi0e = bi0 + lbi0 * il + wbi0 * iw;
        bibe = bib + lbib * il + wbib * iw;
        vghe = vghigh + lvghigh * il + wvghigh * iw;
        vgle = vglow  + lvglow  * il + wvglow  * iw;

        vddc = abs(vdd);
        // b2eval.c:57-59 clamps its LOCAL copies of the three bias arguments
        // before anything else runs:
        //     if (Vbs < B2vbb2) Vbs = B2vbb2;   /* B2vbb2 = 2*VBB, b2temp.c:47 */
        //     if (Vgs > B2vgg2) Vgs = B2vgg2;
        //     if (Vds > B2vdd2) Vds = B2vdd2;
        // VBB is a FLOOR in the code even though b2.c:166 calls it "Maximum
        // Vbs", and b2set.c:388 defaults it to +5 -- so a card that omits VBB is
        // evaluated at Vbs = +10 whatever the real body bias is, which moves
        // T1s/Aa/Vth wholesale (0.665x on devices/bsim2's current). Real cards
        // give VBB negative (devices/bsim2_ngspice: vbb = -3), where it is inert.
        vdd2 = 2.0 * vdd;
        vgg2 = 2.0 * vgg;
        vbb2 = 2.0 * vbb;

        // Diffusion geometry: instance AD/AS/PD/PS when given, else the
        // process defaults (wdf/dell are um, hence 1e-12 to m^2; perimeter
        // falls back to the two channel-width edges).
        asrc = as > 0.0 ? as : wdf * dell * 1.0e-12;
        adrn = ad > 0.0 ? ad : wdf * dell * 1.0e-12;
        psrc = ps > 0.0 ? ps : 2.0 * weff;
        pdrn = pd > 0.0 ? pd : 2.0 * weff;

        // Is = JS * A_{S/D} (mos1 §1.4); the 1e-15 floor is b2ld.c's.
        iss = max(asrc * js, 1.0e-15);
        isd = max(adrn * js, 1.0e-15);
        vcrits = vt * ln(vt / (1.4142135623730951 * iss));
        vcritd = vt * ln(vt / (1.4142135623730951 * isd));
        tyf    = type_;                    // $limit args must be real-typed
        vtx    = vfbe + phie + k1e * sqrt(phie) - k2e * phie;  // zero-bias vth

        // CJ is F/m^2 and CJSW F/m: scale to farads before any charge use.
        czbs   = cj   * asrc;
        czbssw = cjsw * psrc;
        czbd   = cj   * adrn;
        czbdsw = cjsw * pdrn;

        // g = m/(RSH*squares); RSH = 0 collapses the node (mos1 §1.8).
        gdp = rsh > 0.0 ? m / (rsh * max(nrd, 1.0e-6)) : 1.0e12 * m;
        gsp = rsh > 0.0 ? m / (rsh * max(nrs, 1.0e-6)) : 1.0e12 * m;

        omj   = max(1.0 - mj,   0.01);
        omjsw = max(1.0 - mjsw, 0.01);

        // ==================================================================
        // Terminal voltages, type folding and the source/drain swap.
        // §1.7 limiting, mos1.va's ladder: fetlim on both gate legs, limvds
        // on the channel, pnjlim on both bulk junctions (vbsr here, vbdj at
        // the diode block). Trailing tyf = VerA frame sign (PMOS limits
        // type_·v); tyf is type_ as a real — integer $limit args are declined.
        // ==================================================================
        vgsr = tyf * $limit(V(g, sp), "fetlim", vtx, tyf);
        vgdr = tyf * $limit(V(g, dp), "fetlim", vtx, tyf);
        vdsr = tyf * $limit(V(dp, sp), "limvds", tyf);
        vgdr = vgsr - vdsr;
        vbsr = tyf * $limit(V(b, sp), "pnjlim", vt, vcrits, tyf);

        vdsn = min(vdsr, 0.0);                   // swap offset
        // b2eval.c:57-59, applied to the swapped (post-mode) triple, which is
        // what b2ld.c hands B2evaluate. The junction diodes and depletion
        // charges below deliberately stay on the unclamped node voltages: they
        // are computed in b2ld.c, outside B2evaluate, and never see the clamp.
        vbs  = max(vbsr - vdsn, vbb2);
        vgs  = min(vgsr - vdsn, vgg2);
        vds  = min(abs(vdsr), vdd2);
        // Smooth mode sign: +1 forward, -1 reverse.
        mode = vdsr / (abs(vdsr) + 1.0e-30);

        // ==================================================================
        // Threshold voltage and the bulk-charge factor Aa (b2eval.c).
        // The vbs > 0 branch is BSIM2's own continuation (T1s = phi^1.5 /
        // (phi + vbs/2), which equals sqrt(phi) at vbs = 0).
        // ==================================================================
        if (vbs <= 0.0) begin
            phisb = phie - vbs;
            t1s   = sqrt(phisb);
        end else begin
            phisb = phie * phie / (phie + vbs);
            t1s   = phis3 / (phie + 0.5 * vbs);
        end
        eta  = eta0e + etabe * vbs;
        vth  = vfbe + phie + k1e * t1s - k2e * phisb - eta * vds;
        vth0 = vfbe + phie + k1e * t1s;          // threshold without DIBL
        vgst = vgs - vth;

        gg = 1.0 - 1.0 / (1.744 + 0.8364 * phisb);
        aa = max(1.0 + 0.5 * gg * k1e / t1s, 0.1);

        // ==================================================================
        // Vgeff — the Vgg/Vgt transition (doc §1.5). Weak inversion below
        // vgle, Vgst above vghe, a C1 Hermite cubic between the two knots.
        // The weak-inversion Vgeff squared reproduces
        //   Ids = beta*Vt^2*exp(vof)*exp(vgst/(n*Vt))*(1 - exp(-vds/Vt))
        // through the same Ids expression, so no separate multiplicative
        // subthreshold factor (and no additive Isub) is needed.
        // nsub keeps a positive floor; note nb enters as nb/sqrt(phisb), which
        // is what b2eval.c does and is why it cannot flip sign.
        // ==================================================================
        nsub = max(n0e + nbe / t1s + nde * vds, 0.5);
        vof  = vof0e + vofbe * vbs + vofde * vds;

        wds  = 1.0 - exp(-min(max(vds / vt, 0.0), 80.0));
        wpre = sqrt(2.0 * aa * max(wds, 0.0)) * vt;
        vgwk = wpre * exp(min(0.5 * vof + vgst / (2.0 * nsub * vt), 40.0));
        vglo = wpre * exp(min(0.5 * vof + vgle / (2.0 * nsub * vt), 40.0));
        slo  = vglo / (2.0 * nsub * vt);         // d(vgeff)/d(vgst) at vgle

        hspan = max(vghe - vgle, 1.0e-6);
        tsp   = min(max((vgst - vgle) / hspan, 0.0), 1.0);
        if (vgst >= vghe) begin
            vgeff  = vgst;
            dvgeff = 1.0;
        end else if (vgst <= vgle) begin
            vgeff  = vgwk;
            dvgeff = vgwk / (2.0 * nsub * vt);
        end else begin
            h00 = tsp * tsp * (2.0 * tsp - 3.0) + 1.0;
            h10 = tsp * (tsp * (tsp - 2.0) + 1.0);
            h01 = tsp * tsp * (3.0 - 2.0 * tsp);
            h11 = tsp * tsp * (tsp - 1.0);
            vgeff  = h00 * vglo + h10 * hspan * slo + h01 * vghe + h11 * hspan;
            dvgeff = (6.0 * tsp * (tsp - 1.0) * (vglo - vghe)
                      + (tsp * (3.0 * tsp - 4.0) + 1.0) * hspan * slo
                      + tsp * (3.0 * tsp - 2.0) * hspan) / hspan;
        end
        vgeff = max(vgeff, 1.0e-18);

        // ==================================================================
        // Mobility: vertical field (Ua/Ub), lateral field (U1) and the
        // Vds interpolation of beta between its vds = 0 and vds = vdd
        // endpoints. Beta(0) = beta0b and Beta(vdd) = betas identically,
        // which is what makes MUS0/MUSB the vds = vdd endpoint.
        // ==================================================================
        ua    = ua0e + uabe * vbs;
        ub    = ub0e + ubbe * vbs;
        uvert = max(1.0 + vgeff * (ua + vgeff * ub), 0.2);

        u1s   = u10e + u1be * vbs;
        vc    = max(u1s * vgeff / (aa * uvert), 0.0);
        kk    = 0.5 * (1.0 + vc + sqrt(1.0 + 2.0 * vc));
        vdsat = max(vgeff / (aa * sqrt(kk)), 1.0e-18);
        vdsch = min(vds, vdsat);
        t4    = vdsch / vdsat - 1.0;             // 0 at vdsat, -1 at vds = 0
        u1    = u1s * (1.0 - u1de * t4 * t4);

        beta0b = bfac * (mu0   + mu0be * vbs);
        betas  = bfac * (mus0e + musbe * vbs);
        beta2  = mu20e + mu2be * vbs + mu2ge * vgs;          // unitless
        beta3  = bfac * (mu30e + mu3be * vbs + mu3ge * vgs);
        beta4  = bfac * (mu40e + mu4be * vbs + mu4ge * vgs);
        beta1  = betas - (beta0b + vddc * (beta3 - vddc * beta4));
        targ   = max(min(vds * beta2 / vdsat, 30.0), -30.0);
        beta   = max(beta0b + beta1 * tanh(targ) + vds * (beta3 - beta4 * vds),
                     1.0e-18);
        // b2eval.c:274-287: Utot is Uvert PLUS U1*Vds, not Uvert TIMES
        // (1 + U1*Vds), and it floors at 0.5. (b2eval.c's saturation branch is
        // Beta/Uvert with no U1 term at all; vdsch = min(vds, vdsat) reproduces
        // it precisely because Uvert + U1*Vdsat = Uvert*(1 + Vc/sqrt(Kk)) is
        // exactly the factor that cancels (2*sqrt(Kk) - 1) in the triode
        // numerator -- the multiplicative spelling breaks that identity and was
        // 1.13x high on devices/bsim2.)
        betaeff = beta / max(uvert + u1 * vdsch, 0.5);

        // ==================================================================
        // Channel current; vdsch = min(vds, vdsat) unifies triode and
        // saturation (the triode expression evaluated at vdsat is exactly
        // b2eval.c's saturation branch, 0.5*beta*vgeff^2/(Aa*Kk), since
        // sqrt(Kk) = (1 + sqrt(1+2*Vc))/2).
        // ==================================================================
        idscore = betaeff * (vgeff - 0.5 * aa * vdsch) * vdsch;

        // Output-conductance / hot-electron term. ponytail: no has_clm flag —
        // ai=0 makes fclm exactly 1, and clamping the exponent both ways is
        // all the flag was guarding against.
        ai   = ai0e + aibe * vbs;
        bi   = bi0e + bibe * vbs;
        dvds = max(vds - vdsat, 1.0e-20);
        fclm = 1.0 + ai * exp(-max(min(bi / dvds, 30.0), -30.0));

        ids  = max(idscore * fclm, 0.0);
        idst = (ids + 1.0e-12 * vds) * m * type_ * mode;

        // gm for the noise PSD only. ponytail: d(idscore)/d(vgeff) is vdsch in
        // triode and 2*idscore/vgeff in saturation; idscore/(vgeff -
        // 0.5*aa*vdsch) is both at once (at vdsch = vdsat, Kk -> 1, the
        // denominator is exactly vgeff/2). Chain through dvgeff for vgs.
        gmch = idscore * dvgeff / max(vgeff - 0.5 * aa * vdsch, 1.0e-9);

        I(dp, sp) <+ idst;

        // ==================================================================
        // Parasitic series resistances (MOS1 chassis d-dp / s-sp) + their
        // thermal noise (mos-legacy.md noise table).
        // ==================================================================
        I(d, dp) <+ gdp * V(d, dp)
                  + white_noise(4.0 * 1.380649e-23 * tabs * gdp, "rd");
        I(s, sp) <+ gsp * V(s, sp)
                  + white_noise(4.0 * 1.380649e-23 * tabs * gsp, "rs");

        // Channel thermal + flicker noise. The flicker denominator is
        // W*m*Leff*Cox'^2 (mos1noi.c, per the doc's explicit note).
        I(dp, sp) <+ white_noise(4.0 * 1.380649e-23 * tabs * 2.0 / 3.0 * abs(gmch),
                                 "channel");
        if (kf > 0.0) begin
            I(dp, sp) <+ flicker_noise(kf * pow(abs(ids), af)
                                       / (weff * m * leff * cox * cox),
                                       1.0, "flicker");
        end

        // ==================================================================
        // Bulk junction diodes, on the true junction voltages (mode-free),
        // pnjlim'd (vbsr above, vbdj here). Exponent tangent-continued above
        // 80: a flat clamp zeroes the restoring slope on evals at unlimited x
        // (LTE probes, sweep warm starts; see bjt.va pnj).
        // ==================================================================
        vbdj = tyf * $limit(V(b, dp), "pnjlim", vt, vcritd, tyf);
        uj  = min(vbsr / vt, 80.0);
        ibs = iss * (exp(uj) * (1.0 + (vbsr / vt - uj)) - 1.0) + 1.0e-12 * vbsr;
        uj  = min(vbdj / vt, 80.0);
        ibd = isd * (exp(uj) * (1.0 + (vbdj / vt - uj)) - 1.0) + 1.0e-12 * vbdj;
        I(b, sp) <+ m * type_ * ibs;
        I(b, dp) <+ m * type_ * ibd;

        // ==================================================================
        // Charges. Overlaps are linear; the intrinsic channel charge is split
        // gate / bulk / drain so that q(sp) = -(qg + qb + qd) by construction
        // — charge-conserving, doc §2. XPART picks the drain partition:
        // 0 = 40/60, 1 = 0/100. All carry m, as the resistances and the
        // channel current do.
        // ==================================================================
        qgso = cgso * weff * m * V(g, sp);
        qgdo = cgdo * weff * m * V(g, dp);
        qgbo = cgbo * leff * m * V(g, b);

        // port: bsim2.zig's q_g_intr had no outer type_ fold-back, so it
        // disagreed in sign for PMOS. Charges built from the folded voltages
        // are folded charges; type_ converts them back.
        qgch = type_ * m * coxwl * (vgs - vfbe - phie - vgeff / (3.0 * aa));
        qbch = type_ * m * coxwl * (vfbe + phie - vth0
                                    + (1.0 - aa) * vgeff / (3.0 * aa));
        if (xpart > 0) qdch = 0.0;
        else qdch = -type_ * m * (4.0 / 15.0) * coxwl * vgeff;

        qbs = m * type_ * jcharge(type_ * V(b, sp), czbs, czbssw,
                                  pb, pbsw, mj, mjsw, omj, omjsw);
        qbd = m * type_ * jcharge(type_ * V(b, dp), czbd, czbdsw,
                                  pb, pbsw, mj, mjsw, omj, omjsw);

        I(g, sp) <+ ddt(qgso + qgch);
        I(g, dp) <+ ddt(qgdo);
        I(g, b)  <+ ddt(qgbo);
        I(b, sp) <+ ddt(qbs + qbch);
        I(b, dp) <+ ddt(qbd);
        // The channel charge's drain side is dp in forward mode, sp in
        // reverse (everything above is in the swapped frame).
        if (mode >= 0.0) I(dp, sp) <+ ddt(qdch);
        else I(sp, dp) <+ ddt(qdch);
    end
endmodule
