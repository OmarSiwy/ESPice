// Independent current source — ngspice `I` card (ngspice manual §4.1
// "Independent Sources"). Ports the six SPICE transient shapes plus DC off the
// hand-written `modules/devices/src/source/isource.zig` this file replaced; the
// semantics below are ngspice's `src/spicelib/devices/isrc/isrcload.c`, not
// the idealised textbook ones, because the transient benchmark diffs against
// ngspice waveform-for-waveform.
//
// Time source is LRM §9.10 `$abstime`. Every waveform is an explicit function
// of it — no `ddt`/`idt`, no state — so the stamp stays a pure RHS injection
// and the Jacobian is constant.
//
// WAVEFORM SELECTION. `waveform` is an integer discriminant written by the
// netlist binder (src/builder.zig `applySourceWaveform`, `Wave` enum):
//   0 = DC   1 = PULSE   2 = SIN   3 = EXP   4 = PWL   5 = SFFM   6 = AM
// A `.va` cannot take a string parameter and switch on it, and one module per
// shape would multiply the `V` card's binder by six, so the discriminant is
// the encoding. Only the selected arm evaluates (`if`/`else if`, not a
// branchless select chain), so an unused shape costs nothing at runtime.
//
// THE -1 SENTINELS ARE LOAD-BEARING. ngspice `TRANinit` defaults PULSE
// TR = TF = TSTEP and PW = PER = TSTOP, which are properties of the `.tran`
// card, not of the source — unknowable when this model elaborates. The
// defaults below are therefore -1, and src/builder.zig `resolvePulseDefaults`
// patches them from the `.tran` directive. If that pass does not run (a Model
// built directly, e.g. a unit test), the guards here degenerate to
// near-instant edges and a never-falling pulse, i.e. an unspecified PULSE is a
// STEP — which is what ngspice gives you — and never a 2 ns square wave.
//
// BREAKPOINTS. PULSE and PWL have exact corner times; a timestep that steps
// over one smears the edge across the step, which is precisely the transient
// accuracy under benchmark. LRM §5.10.5 `@(timer(start, period))` declares
// those instants, and FastVAF turns the declared set into the generated
// `contract.nextBreakpoint` the engine already asks for. The timer set is:
//   PULSE — 4 periodic timers, one per corner (delay, rise end, fall start,
//           fall end), period = the effective PER. `timer` is a period-based
//           event and a PULSE is a periodic waveform, so this is exact and it
//           reproduces ngspice's PULSE breakpoint set exactly.
//   PWL   — 64 one-shot timers, one per table slot. A PWL corner set is DATA,
//           not a period, so it cannot be one `timer(start, period)`; unused
//           slots read 0 and collapse onto the `pwl_td` breakpoint, which is a
//           real corner anyway, so the extra timers are harmless.
// The timers are UNCONDITIONAL — LRM §5.8 forbids an event control inside an
// `if`, so a source announces the PULSE corners whatever its `waveform` is.
// Sentinels resolved from a `.tran` card: one spurious interior breakpoint at
// t = TD + TSTEP, every other corner at or past TSTOP. Sentinels unresolved
// (P_PW blows P_PER up to ~1e30): breakpoints at TD and TD + 1 ps only. Either
// way it is one extra forced timepoint near t = 0, which costs a step and
// changes no answer.
// ponytail: 64 declared timers is 64×2 f64/bool Instance fields and 64 update
// blocks per timestep, paid by every source in the netlist. The upgrade path is
// a FastVAF `nextBreakpoint` that walks `pwl_times[0:pwl_len-1]` directly;
// delete the timer wall the day that lands.
// LRM §4.5: an analog-operator control argument (here the `timer` corner times)
// must be a CONSTANT OR PARAMETER expression — the host evaluates it outside
// the solve, so a `real` variable is rejected (E0515). These four sentinel
// resolutions are needed twice, once as timer arguments and once as ordinary
// arithmetic in the body, so they live as text macros rather than being
// spelled out twice and drifting apart.
`define P_TR   max(pulse_tr, 1.0e-12)
`define P_TF   max(pulse_tf, 1.0e-12)
// The `-1` sentinel decoded WITHOUT a `?:`: FastVAF's codegen accepts a
// ternary as a timer START but not as a timer PERIOD (E0515), and this
// macro feeds both. The sentinel is exactly -1.0, so `max(-pulse_pw, 0)`
// is exactly 1 when unresolved and exactly 0 for any real width.
`define P_PW   (max(pulse_pw, 0.0) + max(-pulse_pw, 0.0) * 1.0e30)
`define P_PER  max(pulse_per, `P_TR + `P_PW + `P_TF + 1.0e-12)

// PARAMETER SPELLING. The waveform parameters keep the `v` spelling
// (`pulse_v1`, `sin_vo`, `exp_v1`) rather than the `i` spelling the
// hand-written isource.zig used. They are positional SPICE arguments — the
// letter in the name is decoration — and one shared spelling means the binder's
// `applySourceWaveform` table binds `V` and `I` cards through the same field
// names instead of a per-letter fallback that silently bound nothing when the
// two drifted (the old isource.zig's `sffm_ioff`/`am_ia` were never reachable
// from src/builder.zig's `fieldPairs`, which only ever spelled them `sffm_vo`/
// `am_va`).
module isource(p, n);
    inout p, n;
    electrical p, n;

    // ---- DC / AC -----------------------------------------------------------
    parameter real dc      = 0.0;   // A   operating-point value
    parameter real acmag   = 1.0;   // A   .AC magnitude
    parameter real acphase = 0.0;   // deg .AC phase
    parameter integer waveform = 0; //     shape discriminant, see header

    // ---- PULSE(I1 I2 TD TR TF PW PER PHASE) -----------------------------------
    parameter real pulse_v1    =  0.0;  // A   initial value
    parameter real pulse_v2    =  0.0;  // A   pulsed value
    parameter real pulse_td    =  0.0;  // s   delay
    parameter real pulse_tr    = -1.0;  // s   rise time   (-1 = TSTEP)
    parameter real pulse_tf    = -1.0;  // s   fall time   (-1 = TSTEP)
    parameter real pulse_pw    = -1.0;  // s   pulse width (-1 = TSTOP)
    parameter real pulse_per   = -1.0;  // s   period      (-1 = TSTOP)
    parameter real pulse_phase =  0.0;  // deg phase offset into the period

    // ---- SIN(IO IA FREQ TD THETA PHASE) ---------------------------------------
    parameter real sin_vo    = 0.0;  // A     offset
    parameter real sin_va    = 0.0;  // A     amplitude
    parameter real sin_freq  = 0.0;  // Hz
    parameter real sin_td    = 0.0;  // s      delay
    parameter real sin_theta = 0.0;  // 1/s    damping factor
    parameter real sin_phase = 0.0;  // deg

    // ---- EXP(I1 I2 TD1 TAU1 TD2 TAU2) -----------------------------------------
    parameter real exp_v1   = 0.0;      // A
    parameter real exp_v2   = 0.0;      // A
    parameter real exp_td1  = 0.0;      // s  rise delay
    parameter real exp_tau1 = 1.0e-9;   // s  rise time constant
    parameter real exp_td2  = 0.0;      // s  fall delay
    parameter real exp_tau2 = 1.0e-9;   // s  fall time constant

    // ---- PWL(T1 I1 T2 I2 ... [R=<t>] [TD=<t>]) --------------------------------
    // Flat arrays, not a table type: FastVAF flattens `real x[0:63]` into 64
    // scalar Model fields, so there is no memory to index. VerA turns a RUNTIME
    // index over them into ONE `switch` (see lower.zig lowerIndex), which is a
    // constant number of instructions in the array's extent — so the bisection
    // below costs ceil(log2(pwl_len)) reads and never touches an unfilled slot.
    //
    // ponytail: bisection, not ngspice's per-instance breakpoint cursor. A
    // cursor is O(1) instead of O(log n), but the saving is ~3 switch
    // dispatches on a 10-point table and it is STATE that has to rewind
    // correctly when a rejected step moves `t` backwards. Bisection is
    // stateless, so it is right across a reject by construction. Upgrade path
    // if a deck ever ships a 1000-point table: an Instance cursor latched in
    // updateState and reverted by stateCtl(.revert), with the bisection kept
    // as the oracle it has to agree with.
    parameter real pwl_times[0:63]  = '{0.0, 0.0, 0.0, 0.0, 0.0, 0.0, 0.0, 0.0, 0.0, 0.0, 0.0, 0.0, 0.0, 0.0, 0.0, 0.0, 0.0, 0.0, 0.0, 0.0, 0.0, 0.0, 0.0, 0.0, 0.0, 0.0, 0.0, 0.0, 0.0, 0.0, 0.0, 0.0, 0.0, 0.0, 0.0, 0.0, 0.0, 0.0, 0.0, 0.0, 0.0, 0.0, 0.0, 0.0, 0.0, 0.0, 0.0, 0.0, 0.0, 0.0, 0.0, 0.0, 0.0, 0.0, 0.0, 0.0, 0.0, 0.0, 0.0, 0.0, 0.0, 0.0, 0.0, 0.0};
    parameter real pwl_values[0:63] = '{0.0, 0.0, 0.0, 0.0, 0.0, 0.0, 0.0, 0.0, 0.0, 0.0, 0.0, 0.0, 0.0, 0.0, 0.0, 0.0, 0.0, 0.0, 0.0, 0.0, 0.0, 0.0, 0.0, 0.0, 0.0, 0.0, 0.0, 0.0, 0.0, 0.0, 0.0, 0.0, 0.0, 0.0, 0.0, 0.0, 0.0, 0.0, 0.0, 0.0, 0.0, 0.0, 0.0, 0.0, 0.0, 0.0, 0.0, 0.0, 0.0, 0.0, 0.0, 0.0, 0.0, 0.0, 0.0, 0.0, 0.0, 0.0, 0.0, 0.0, 0.0, 0.0, 0.0, 0.0};
    parameter integer pwl_len = 0;      //     points actually filled
    parameter real pwl_repeat = 0.0;    // s   ngspice `r=<t>`: replay [r, t_last]
    parameter real pwl_td     = 0.0;    // s   ngspice `td=<t>`

    // ---- SFFM(IO IA FC MDI FS PHASEC PHASES) ----------------------------------
    parameter real sffm_vo     = 0.0;  // A
    parameter real sffm_va     = 0.0;  // A
    parameter real sffm_fc     = 0.0;  // Hz  carrier
    parameter real sffm_mdi    = 0.0;  //     modulation index
    parameter real sffm_fs     = 0.0;  // Hz  signal
    parameter real sffm_phasec = 0.0;  // deg
    parameter real sffm_phases = 0.0;  // deg

    // ---- AM(IA IO MF FC TD PHASEC PHASES) -------------------------------------
    parameter real am_va     = 0.0;  // A   amplitude
    parameter real am_vo     = 0.0;  //     modulation-envelope offset (unitless)
    parameter real am_mf     = 0.0;  // Hz  modulating frequency
    parameter real am_fc     = 0.0;  // Hz  carrier frequency
    parameter real am_td     = 0.0;  // s   delay
    parameter real am_phasec = 0.0;  // deg
    parameter real am_phases = 0.0;  // deg

    real t, out;
    // PULSE, sentinel-resolved (see header) — also the timer arguments.
    real p_tr, p_tf, p_pw, p_per, t_rel, t_mod;
    real t_sin, t_e1, t_e2, fm_mod, am_env, am_car;
    real t_e, t_first, t_last, v_first, v_last, tp, vp, tk, vk, span, excess;
    integer k, klo, khi;

    analog begin
        // §5.10.5 corner-time events — see the BREAKPOINTS note in the header.
        @(timer(pulse_td, `P_PER)) ;
        @(timer(pulse_td + `P_TR, `P_PER)) ;
        @(timer(pulse_td + `P_TR + `P_PW, `P_PER)) ;
        @(timer(pulse_td + `P_TR + `P_PW + `P_TF, `P_PER)) ;
        @(timer(pwl_times[0] + pwl_td)) ;
        @(timer(pwl_times[1] + pwl_td)) ;
        @(timer(pwl_times[2] + pwl_td)) ;
        @(timer(pwl_times[3] + pwl_td)) ;
        @(timer(pwl_times[4] + pwl_td)) ;
        @(timer(pwl_times[5] + pwl_td)) ;
        @(timer(pwl_times[6] + pwl_td)) ;
        @(timer(pwl_times[7] + pwl_td)) ;
        @(timer(pwl_times[8] + pwl_td)) ;
        @(timer(pwl_times[9] + pwl_td)) ;
        @(timer(pwl_times[10] + pwl_td)) ;
        @(timer(pwl_times[11] + pwl_td)) ;
        @(timer(pwl_times[12] + pwl_td)) ;
        @(timer(pwl_times[13] + pwl_td)) ;
        @(timer(pwl_times[14] + pwl_td)) ;
        @(timer(pwl_times[15] + pwl_td)) ;
        @(timer(pwl_times[16] + pwl_td)) ;
        @(timer(pwl_times[17] + pwl_td)) ;
        @(timer(pwl_times[18] + pwl_td)) ;
        @(timer(pwl_times[19] + pwl_td)) ;
        @(timer(pwl_times[20] + pwl_td)) ;
        @(timer(pwl_times[21] + pwl_td)) ;
        @(timer(pwl_times[22] + pwl_td)) ;
        @(timer(pwl_times[23] + pwl_td)) ;
        @(timer(pwl_times[24] + pwl_td)) ;
        @(timer(pwl_times[25] + pwl_td)) ;
        @(timer(pwl_times[26] + pwl_td)) ;
        @(timer(pwl_times[27] + pwl_td)) ;
        @(timer(pwl_times[28] + pwl_td)) ;
        @(timer(pwl_times[29] + pwl_td)) ;
        @(timer(pwl_times[30] + pwl_td)) ;
        @(timer(pwl_times[31] + pwl_td)) ;
        @(timer(pwl_times[32] + pwl_td)) ;
        @(timer(pwl_times[33] + pwl_td)) ;
        @(timer(pwl_times[34] + pwl_td)) ;
        @(timer(pwl_times[35] + pwl_td)) ;
        @(timer(pwl_times[36] + pwl_td)) ;
        @(timer(pwl_times[37] + pwl_td)) ;
        @(timer(pwl_times[38] + pwl_td)) ;
        @(timer(pwl_times[39] + pwl_td)) ;
        @(timer(pwl_times[40] + pwl_td)) ;
        @(timer(pwl_times[41] + pwl_td)) ;
        @(timer(pwl_times[42] + pwl_td)) ;
        @(timer(pwl_times[43] + pwl_td)) ;
        @(timer(pwl_times[44] + pwl_td)) ;
        @(timer(pwl_times[45] + pwl_td)) ;
        @(timer(pwl_times[46] + pwl_td)) ;
        @(timer(pwl_times[47] + pwl_td)) ;
        @(timer(pwl_times[48] + pwl_td)) ;
        @(timer(pwl_times[49] + pwl_td)) ;
        @(timer(pwl_times[50] + pwl_td)) ;
        @(timer(pwl_times[51] + pwl_td)) ;
        @(timer(pwl_times[52] + pwl_td)) ;
        @(timer(pwl_times[53] + pwl_td)) ;
        @(timer(pwl_times[54] + pwl_td)) ;
        @(timer(pwl_times[55] + pwl_td)) ;
        @(timer(pwl_times[56] + pwl_td)) ;
        @(timer(pwl_times[57] + pwl_td)) ;
        @(timer(pwl_times[58] + pwl_td)) ;
        @(timer(pwl_times[59] + pwl_td)) ;
        @(timer(pwl_times[60] + pwl_td)) ;
        @(timer(pwl_times[61] + pwl_td)) ;
        @(timer(pwl_times[62] + pwl_td)) ;
        @(timer(pwl_times[63] + pwl_td)) ;

        t = $abstime;

        // ngspice `vsrctemp`: a zero/absent TR or TF is an INSTANT edge, which
        // as a divisor is a NaN — 1 ps is the smallest edge the engine can
        // resolve and keeps the ramp arms finite (LRM §4.3 finiteness).
        p_tr = `P_TR;
        p_tf = `P_TF;
        // Unresolved PW/PER sentinel: "high forever", i.e. a step.
        p_pw = `P_PW;
        // A PER shorter than one full cycle would alias the shape onto itself;
        // ngspice clamps it up to TR+PW+TF. Also guards PER = 0 in the modulo.
        p_per = `P_PER;

        out = dc;

        // ngspice's TRANOP/DCOP split (vsource.va says why): the transient's
        // ic-phase op evaluates waveform(0); every other static analysis
        // biases at `dc`, which bind fills from waveform(0) when absent and
        // a .dc sweep overrides.
        if (analysis("static") && !analysis("tran")) begin
            out = dc;
        end else if (waveform == 1) begin
            // ---- PULSE ----------------------------------------------------
            // ngspice holds V1 until TD, then repeats the trapezoid with
            // period PER. PHASE is a fraction of the period, not of 2*pi.
            t_rel = t - pulse_td;
            t_mod = t_rel + (pulse_phase / 360.0) * p_per;
            t_mod = t_mod - floor(t_mod / p_per) * p_per;
            t_mod = max(t_mod, 0.0);
            if (t_rel < 0.0)                     out = pulse_v1;
            else if (t_mod < p_tr)               out = pulse_v1 + (pulse_v2 - pulse_v1) * (t_mod / p_tr);
            else if (t_mod < p_tr + p_pw)        out = pulse_v2;
            else if (t_mod < p_tr + p_pw + p_tf) out = pulse_v2 - (pulse_v2 - pulse_v1) * ((t_mod - (p_tr + p_pw)) / p_tf);
            else                                 out = pulse_v1;

        end else if (waveform == 2) begin
            // ---- SIN ------------------------------------------------------
            // Before TD ngspice emits VO + VA*sin(PHASE) — the waveform's own
            // t=0 value, NOT VO, so a phase-shifted SIN does not step at TD.
            // The damping envelope exp(-THETA*(t-TD)) applies only after TD.
            t_sin = t - sin_td;
            if (t_sin < 0.0)
                out = sin_vo + sin_va * sin(sin_phase * `M_PI / 180.0);
            else
                // Clamp the exponent: THETA*t overflows to -inf long before it
                // means anything, and exp(-inf) is a legal 0 but the prover
                // cannot see that the product stays finite.
                out = sin_vo + sin_va
                    * sin(`M_TWO_PI * sin_freq * t_sin + sin_phase * `M_PI / 180.0)
                    * exp(min(-sin_theta * t_sin, 80.0));

        end else if (waveform == 3) begin
            // ---- EXP ------------------------------------------------------
            // ngspice superposes two independent one-sided exponentials on V1;
            // they are NOT exclusive, which is why TD2 < TD1 still produces a
            // sensible (if odd) waveform instead of a discontinuity.
            t_e1 = t - exp_td1;
            t_e2 = t - exp_td2;
            out = exp_v1;
            if (t_e1 > 0.0) out = out + (exp_v2 - exp_v1) * (1.0 - exp(min(-t_e1 / max(exp_tau1, 1.0e-15), 80.0)));
            if (t_e2 > 0.0) out = out + (exp_v1 - exp_v2) * (1.0 - exp(min(-t_e2 / max(exp_tau2, 1.0e-15), 80.0)));

        end else if (waveform == 4) begin
            // ---- PWL ------------------------------------------------------
            // An empty table is not an error in ngspice, it is just the DC
            // value; `out` already holds it.
            if (pwl_len > 0) begin
                t_e = t - pwl_td;
                t_first = pwl_times[0];
                v_first = pwl_values[0];
                t_last = pwl_times[pwl_len - 1];
                v_last = pwl_values[pwl_len - 1];

                // ngspice `r=<t>`: past the last point, jump back to time `r`
                // and replay [r, t_last] forever.
                if (pwl_repeat > 0.0 && pwl_len > 1 && t_e > t_last && t_last > pwl_repeat) begin
                    span = t_last - pwl_repeat;
                    if (span > 0.0) begin
                        excess = t_e - pwl_repeat;
                        t_e = pwl_repeat + (excess - floor(excess / span) * span);
                    end
                end

                if (t_e < 0.0 || t_e <= t_first)  out = v_first;
                else if (t_e >= t_last)           out = v_last;
                else begin
                    // BISECTION, not a scan: a PWL table is sorted in t, so the
                    // bracketing segment is found in ceil(log2(pwl_len)) reads
                    // instead of pwl_len. Loop invariant, established by the two
                    // guards above (t_first < t_e < t_last):
                    //     pwl_times[klo] <= t_e < pwl_times[khi]
                    // and each step halves khi-klo, so it exits at khi=klo+1 —
                    // the smallest khi with pwl_times[khi] > t_e.
                    //
                    // It is the SAME segment the linear scan this replaced
                    // picked. That scan took every k with t[k-1] <= t_e < t[k];
                    // for non-decreasing t only ONE k satisfies both (t[k] > t_e
                    // is upward-closed from khi, t[k-1] <= t_e downward-closed
                    // to khi), so its last write was khi too — a repeated knot
                    // included, where the zero-width segment satisfies neither
                    // half. Same segment through the same expression below is
                    // the same bits, which is the conformance claim.
                    klo = 0;
                    khi = pwl_len - 1;
                    while (khi - klo > 1) begin
                        k = (klo + khi) / 2;
                        if (pwl_times[k] > t_e) khi = k; else klo = k;
                    end
                    tp = pwl_times[klo];
                    vp = pwl_values[klo];
                    tk = pwl_times[khi];
                    vk = pwl_values[khi];
                    // Coincident times (a vertical step) would divide by
                    // zero; 1 fs makes it the steepest ramp we can express.
                    out = vp + (vk - vp) * (t_e - tp) / max(tk - tp, 1.0e-15);
                end
            end

        end else if (waveform == 5) begin
            // ---- SFFM -----------------------------------------------------
            // Single-frequency FM. ngspice applies no delay to SFFM and both
            // phases are in degrees.
            fm_mod = sffm_mdi * sin(`M_TWO_PI * sffm_fs * t + sffm_phases * `M_PI / 180.0);
            out = sffm_vo + sffm_va * sin(`M_TWO_PI * sffm_fc * t + sffm_phasec * `M_PI / 180.0 + fm_mod);

        end else if (waveform == 6) begin
            // ---- AM -------------------------------------------------------
            // ngspice: out = VA * (VO + sin(2*pi*MF*t + PHASES))
            //               * sin(2*pi*FC*t + PHASEC), and hard 0 before TD —
            // the envelope offset VO is dimensionless, it is not an output
            // offset, so before TD the source is 0 and not VA*VO.
            if (t >= am_td) begin
                am_env = am_vo + sin(`M_TWO_PI * am_mf * t + am_phases * `M_PI / 180.0);
                am_car = sin(`M_TWO_PI * am_fc * t + am_phasec * `M_PI / 180.0);
                out = am_va * am_env * am_car;
            end else
                out = 0.0;
        end

        I(p, n) <+ out;
    end
endmodule

`undef P_TR
`undef P_TF
`undef P_PW
`undef P_PER
