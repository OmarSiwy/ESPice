// Linear resistor. i(p,n) = V(p,n) / r.
module resistor(p, n);
    inout p, n;
    electrical p, n;
    parameter real r = 1000.0 from (0:inf);

    analog I(p, n) <+ V(p, n) / r;
endmodule
