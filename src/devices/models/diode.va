// Junction diode, ngspice `.model D` (dioload.c / diotemp.c).
//
// Was the bare Shockley law with four parameters (is, n, tnom, gmin), so a
// card naming RS, IKF, BV or IBV was silently reduced to an ideal
// exponential: devices/diode_breakdown ran straight past its -15 V knee to
// -20 V, and devices/diode_high_injection overflowed to NaN at exactly
// V1 = 1.38 V because nothing restrained the forward current.
//
// RS is a real series resistance, so the junction sits on an internal node
// `ai` and the card's terminals stay (a, c). With RS=0 the branch is a 0 V
// short and the host collapses the node (Builder.addDevice, `collapse`).
//
// Junction limiting stays the solver's job ($limit pnjlim below, with
// ngspice's vcrit = vte*ln(vte/(sqrt(2)*is))). The exponent is additionally
// tangent-continued past 80*vte — NOT at vcrit: vcrit is a step-limiting
// threshold, and converged operating points sit above it (a 1N-style diode
// at 50 mA runs vd ~ 0.64 V vs vcrit ~ 0.61 V; clamping there flattened
// the I-V and cost power/rectifier 0.3 of waveform). 80*vte only guards
// unlimited evals (LTE probes, sweeps): finite, monotone, correct slope.
//
// ponytail: TT transit time and XTI/EG temperature scaling are NOT here.
// devices/diode_temp DOES now exercise temperature (the `.dc … TEMP` outer
// sweep and branch-current comparison both landed 2026-09) and shows the
// gap — ~2e-2 on i(v1) across -40..125 C. A first inline IS(T)=IS·
// (T/Tnom)^(XTI/N)·exp((EG/N·vt)(T/Tnom-1)) made it WORSE (4.7e-2): ngspice
// diotemp.c also scales vj/cjo and uses a temperature-dependent egfet, so
// the full port has to land together and be verified point-by-point
// against diotemp.c — a focused task, not an inline guess.
module diode(a, c);
    inout a, c;
    electrical a, c, ai;
    branch (a, ai) rsb;

    parameter real is   = 1e-14  from (0:inf);  // A    saturation current
    parameter real n    = 1.0    from (0:inf);  //      emission coefficient
    parameter real rs   = 0.0    from [0:inf);  // ohm  series resistance
    parameter real ikf  = 0.0    from [0:inf);  // A    high-injection knee (0 = off)
    parameter real isr  = 0.0    from [0:inf);  // A    recombination sat current (0 = off)
    parameter real nr   = 2.0    from (0:inf);  //      recombination emission coefficient
    parameter real bv   = 0.0    from [0:inf);  // V    reverse breakdown knee (0 = off)
    parameter real ibv  = 1e-3   from (0:inf);  // A    current magnitude at bv
    parameter real cjo  = 0.0    from [0:inf);  // F    zero-bias junction capacitance
    parameter real vj   = 1.0    from (0:inf);  // V    junction potential
    parameter real m    = 0.5    from (0:inf);  //      grading coefficient (card key `m`)
    parameter real fc   = 0.5    from (0:1);    //      forward-bias depletion coefficient
    parameter real tnom = 300.15 from (0:inf);  // K
    parameter real gmin = 1e-12  from [0:inf);  // S    junction shunt

    real vt, vte, vd, vcrit, u, ulim, id, ihi, w, wlim, qj, f1, f2, f3, vfc;
    real vterec, ur, urlim, genfac, irec;

    analog begin
        vt  = 1.380649e-23 * tnom / 1.602176634e-19;
        vte = n * vt;
        // pnjlim first, exactly where dioload.c:66 runs it: Newton must not
        // hand the exponential a rail voltage. The tangent continuation below
        // stays as the guard for evals at unlimited x (LTE probes, sweeps).
        vcrit = vte * ln(vte / (1.4142135623730951 * is));
        vd  = $limit(V(ai, c), "pnjlim", vte, vcrit);

        // Forward/reverse ideal current, tangent-continued past 80*vte.
        // Ratio-space clamp so the finiteness prover sees exp's argument
        // bounded by the literal 80 (same pattern as breakdown below).
        u     = vd / vte;
        ulim  = min(u, 80.0);
        id    = is * ((exp(ulim) * (1.0 + (u - ulim))) - 1.0);

        // ISR/NR recombination current (dioload.c:311-317), forward region
        // only (dioload's vd >= -3*vte branch): isr*(e^{vd/(nr*vt)}-1) times
        // the depletion generation factor ((1-vd/vj)^2+0.005)^(m/2). NR
        // multiplies the raw vt, not vte. Same tangent continuation past 80.
        irec = 0.0;
        if (isr > 0.0 && vd >= -3.0 * vte) begin
            vterec = nr * vt;
            ur     = vd / vterec;
            urlim  = min(ur, 80.0);
            genfac = pow((1.0 - vd / vj) * (1.0 - vd / vj) + 0.005, m / 2.0);
            irec   = isr * ((exp(urlim) * (1.0 + (ur - urlim))) - 1.0) * genfac;
        end

        // High-injection roll-off, ngspice IKF (dioload.c:382-386):
        // cd / (1 + sqrt(cd/ikf)) on the total forward current, recombination
        // included. Guarded on itot > 0 so the reverse branch is untouched
        // and the sqrt argument cannot go negative.
        ihi = id + irec;
        if (ikf > 0.0 && ihi > 0.0)
            ihi = ihi / (1.0 + sqrt(ihi / ikf));

        // Reverse breakdown: -ibv at vd = -bv, exponential below. Armed only
        // when the card gives a BV, which is how ngspice treats BV=0.
        // Tangent-continued past 80*vt of depth: ngspice instead runs a
        // MIRRORED pnjlim in this region (dioload.c:59), which the probe-only
        // $limit form cannot spell; the tangent keeps slope structure so
        // Newton walks back instead of meeting inf.
        // Ratio-space clamp (w/vt before min) so the finiteness prover sees
        // exp's argument bounded by the literal 80.
        if (bv > 0.0 && vd < -bv) begin
            w    = -(bv + vd) / vt;
            wlim = min(w, 80.0);
            ihi  = ihi - ibv * (exp(wlim) * (1.0 + (w - wlim)) - 1.0);
        end

        I(ai, c) <+ ihi + gmin * vd;

        // Depletion charge, ngspice CJO/VJ/M. Below fc*vj it is the exact
        // integral of cjo*(1-v/vj)^-m; above it ngspice switches to the
        // linearized f1/f2/f3 continuation, because the exact form has a
        // singularity at v = vj that a forward-biased Newton step walks into.
        if (cjo > 0.0) begin
            vfc = fc * vj;
            if (vd < vfc) begin
                qj = cjo * vj * (1.0 - pow(1.0 - vd / vj, 1.0 - m)) / (1.0 - m);
            end else begin
                f1 = vj * (1.0 - pow(1.0 - fc, 1.0 - m)) / (1.0 - m);
                f2 = pow(1.0 - fc, 1.0 + m);
                f3 = 1.0 - fc * (1.0 + m);
                qj = cjo * (f1 + (1.0 / f2) *
                     (f3 * (vd - vfc) + (m / (2.0 * vj)) * (vd * vd - vfc * vfc)));
            end
            I(ai, c) <+ ddt(qj);
        end

        if (rs > 0.0) I(rsb) <+ V(rsb) / rs;
        else          V(rsb) <+ 0.0;
    end
endmodule
