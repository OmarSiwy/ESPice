Voltage divider
* A 10 V source across 1k over 3k.
V1 in 0 DC 10
R1 in out 1k
R2 out 0 3k
.op
.end
