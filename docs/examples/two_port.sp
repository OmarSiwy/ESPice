LC low-pass as a two-port
* Each port is a V card with portnum and z0.
VP1 in 0 DC 0 AC 1 portnum 1 z0 50
C1 in 0 31.8p
L1 in out 159n
C2 out 0 31.8p
VP2 out 0 DC 0 portnum 2 z0 50
.sp dec 10 1meg 1g
.end
