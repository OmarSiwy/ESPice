Divider spread with Monte Carlo
* .mc N SIGMA: N trials, each nonzero primary value drawn with relative sigma.
V1 in 0 DC 1
R1 in out 1k
R2 out 0 1k
.mc 200 0.01
.end
