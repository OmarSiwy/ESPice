Divider with a Verilog-A resistor
.hdl "vres.va"
V1 in 0 DC 1
R1 in out 1k
N1 out 0 vres r=3k
.op
.end
